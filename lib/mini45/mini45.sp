* mini45 transistor netlists: one .subckt per cell, pins in the order of the
* Liberty cell (inputs, then outputs), then vdd and vss. Models nch and pch come
* from mini45_models_<corner>.sp. Generated by gen_mini45.py; do not edit.

.subckt inv_x1 a y vdd vss
m1 Y A vss vss nch w=0.2u l=0.05u ad=0.02p as=0.02p pd=0.6u ps=0.6u
m2 vdd A Y vdd pch w=0.3u l=0.05u ad=0.03p as=0.03p pd=0.8u ps=0.8u
.ends

.subckt inv_x2 a y vdd vss
m1 Y A vss vss nch w=0.4u l=0.05u ad=0.04p as=0.04p pd=1u ps=1u
m2 vdd A Y vdd pch w=0.6u l=0.05u ad=0.06p as=0.06p pd=1.4u ps=1.4u
.ends

.subckt inv_x4 a y vdd vss
m1 Y A vss vss nch w=0.8u l=0.05u ad=0.08p as=0.08p pd=1.8u ps=1.8u
m2 vdd A Y vdd pch w=1.2u l=0.05u ad=0.12p as=0.12p pd=2.6u ps=2.6u
.ends

.subckt inv_x8 a y vdd vss
m1 Y A vss vss nch w=1.6u l=0.05u ad=0.16p as=0.16p pd=3.4u ps=3.4u
m2 vdd A Y vdd pch w=2.4u l=0.05u ad=0.24p as=0.24p pd=5u ps=5u
.ends

.subckt buf_x1 a y vdd vss
m1 n1 A vss vss nch w=0.2u l=0.05u ad=0.02p as=0.02p pd=0.6u ps=0.6u
m2 vdd A n1 vdd pch w=0.3u l=0.05u ad=0.03p as=0.03p pd=0.8u ps=0.8u
m3 Y n1 vss vss nch w=0.2u l=0.05u ad=0.02p as=0.02p pd=0.6u ps=0.6u
m4 vdd n1 Y vdd pch w=0.3u l=0.05u ad=0.03p as=0.03p pd=0.8u ps=0.8u
.ends

.subckt buf_x2 a y vdd vss
m1 n1 A vss vss nch w=0.2u l=0.05u ad=0.02p as=0.02p pd=0.6u ps=0.6u
m2 vdd A n1 vdd pch w=0.3u l=0.05u ad=0.03p as=0.03p pd=0.8u ps=0.8u
m3 Y n1 vss vss nch w=0.4u l=0.05u ad=0.04p as=0.04p pd=1u ps=1u
m4 vdd n1 Y vdd pch w=0.6u l=0.05u ad=0.06p as=0.06p pd=1.4u ps=1.4u
.ends

.subckt buf_x4 a y vdd vss
m1 n1 A vss vss nch w=0.26667u l=0.05u ad=0.02667p as=0.02667p pd=0.73333u ps=0.73333u
m2 vdd A n1 vdd pch w=0.4u l=0.05u ad=0.04p as=0.04p pd=1u ps=1u
m3 Y n1 vss vss nch w=0.8u l=0.05u ad=0.08p as=0.08p pd=1.8u ps=1.8u
m4 vdd n1 Y vdd pch w=1.2u l=0.05u ad=0.12p as=0.12p pd=2.6u ps=2.6u
.ends

.subckt buf_x8 a y vdd vss
m1 n1 A vss vss nch w=0.53333u l=0.05u ad=0.05333p as=0.05333p pd=1.26667u ps=1.26667u
m2 vdd A n1 vdd pch w=0.8u l=0.05u ad=0.08p as=0.08p pd=1.8u ps=1.8u
m3 Y n1 vss vss nch w=1.6u l=0.05u ad=0.16p as=0.16p pd=3.4u ps=3.4u
m4 vdd n1 Y vdd pch w=2.4u l=0.05u ad=0.24p as=0.24p pd=5u ps=5u
.ends

.subckt clkbuf_x1 a y vdd vss
m1 n1 A vss vss nch w=0.2u l=0.05u ad=0.02p as=0.02p pd=0.6u ps=0.6u
m2 vdd A n1 vdd pch w=0.3u l=0.05u ad=0.03p as=0.03p pd=0.8u ps=0.8u
m3 Y n1 vss vss nch w=0.2u l=0.05u ad=0.02p as=0.02p pd=0.6u ps=0.6u
m4 vdd n1 Y vdd pch w=0.3u l=0.05u ad=0.03p as=0.03p pd=0.8u ps=0.8u
.ends

.subckt clkbuf_x2 a y vdd vss
m1 n1 A vss vss nch w=0.2u l=0.05u ad=0.02p as=0.02p pd=0.6u ps=0.6u
m2 vdd A n1 vdd pch w=0.3u l=0.05u ad=0.03p as=0.03p pd=0.8u ps=0.8u
m3 Y n1 vss vss nch w=0.4u l=0.05u ad=0.04p as=0.04p pd=1u ps=1u
m4 vdd n1 Y vdd pch w=0.6u l=0.05u ad=0.06p as=0.06p pd=1.4u ps=1.4u
.ends

.subckt clkbuf_x4 a y vdd vss
m1 n1 A vss vss nch w=0.26667u l=0.05u ad=0.02667p as=0.02667p pd=0.73333u ps=0.73333u
m2 vdd A n1 vdd pch w=0.4u l=0.05u ad=0.04p as=0.04p pd=1u ps=1u
m3 Y n1 vss vss nch w=0.8u l=0.05u ad=0.08p as=0.08p pd=1.8u ps=1.8u
m4 vdd n1 Y vdd pch w=1.2u l=0.05u ad=0.12p as=0.12p pd=2.6u ps=2.6u
.ends

.subckt clkinv_x1 a y vdd vss
m1 Y A vss vss nch w=0.2u l=0.05u ad=0.02p as=0.02p pd=0.6u ps=0.6u
m2 vdd A Y vdd pch w=0.3u l=0.05u ad=0.03p as=0.03p pd=0.8u ps=0.8u
.ends

.subckt clkinv_x2 a y vdd vss
m1 Y A vss vss nch w=0.4u l=0.05u ad=0.04p as=0.04p pd=1u ps=1u
m2 vdd A Y vdd pch w=0.6u l=0.05u ad=0.06p as=0.06p pd=1.4u ps=1.4u
.ends

.subckt clkinv_x4 a y vdd vss
m1 Y A vss vss nch w=0.8u l=0.05u ad=0.08p as=0.08p pd=1.8u ps=1.8u
m2 vdd A Y vdd pch w=1.2u l=0.05u ad=0.12p as=0.12p pd=2.6u ps=2.6u
.ends

.subckt nand2_x1 a b y vdd vss
m1 Y A n1 vss nch w=0.4u l=0.05u ad=0.04p as=0.04p pd=1u ps=1u
m2 n1 B vss vss nch w=0.4u l=0.05u ad=0.04p as=0.04p pd=1u ps=1u
m3 vdd A Y vdd pch w=0.3u l=0.05u ad=0.03p as=0.03p pd=0.8u ps=0.8u
m4 vdd B Y vdd pch w=0.3u l=0.05u ad=0.03p as=0.03p pd=0.8u ps=0.8u
.ends

.subckt nand2_x2 a b y vdd vss
m1 Y A n1 vss nch w=0.8u l=0.05u ad=0.08p as=0.08p pd=1.8u ps=1.8u
m2 n1 B vss vss nch w=0.8u l=0.05u ad=0.08p as=0.08p pd=1.8u ps=1.8u
m3 vdd A Y vdd pch w=0.6u l=0.05u ad=0.06p as=0.06p pd=1.4u ps=1.4u
m4 vdd B Y vdd pch w=0.6u l=0.05u ad=0.06p as=0.06p pd=1.4u ps=1.4u
.ends

.subckt nand2_x4 a b y vdd vss
m1 Y A n1 vss nch w=1.6u l=0.05u ad=0.16p as=0.16p pd=3.4u ps=3.4u
m2 n1 B vss vss nch w=1.6u l=0.05u ad=0.16p as=0.16p pd=3.4u ps=3.4u
m3 vdd A Y vdd pch w=1.2u l=0.05u ad=0.12p as=0.12p pd=2.6u ps=2.6u
m4 vdd B Y vdd pch w=1.2u l=0.05u ad=0.12p as=0.12p pd=2.6u ps=2.6u
.ends

.subckt and2_x1 a b y vdd vss
m1 n1 A n2 vss nch w=0.4u l=0.05u ad=0.04p as=0.04p pd=1u ps=1u
m2 n2 B vss vss nch w=0.4u l=0.05u ad=0.04p as=0.04p pd=1u ps=1u
m3 vdd A n1 vdd pch w=0.3u l=0.05u ad=0.03p as=0.03p pd=0.8u ps=0.8u
m4 vdd B n1 vdd pch w=0.3u l=0.05u ad=0.03p as=0.03p pd=0.8u ps=0.8u
m5 Y n1 vss vss nch w=0.2u l=0.05u ad=0.02p as=0.02p pd=0.6u ps=0.6u
m6 vdd n1 Y vdd pch w=0.3u l=0.05u ad=0.03p as=0.03p pd=0.8u ps=0.8u
.ends

.subckt and2_x2 a b y vdd vss
m1 n1 A n2 vss nch w=0.4u l=0.05u ad=0.04p as=0.04p pd=1u ps=1u
m2 n2 B vss vss nch w=0.4u l=0.05u ad=0.04p as=0.04p pd=1u ps=1u
m3 vdd A n1 vdd pch w=0.3u l=0.05u ad=0.03p as=0.03p pd=0.8u ps=0.8u
m4 vdd B n1 vdd pch w=0.3u l=0.05u ad=0.03p as=0.03p pd=0.8u ps=0.8u
m5 Y n1 vss vss nch w=0.4u l=0.05u ad=0.04p as=0.04p pd=1u ps=1u
m6 vdd n1 Y vdd pch w=0.6u l=0.05u ad=0.06p as=0.06p pd=1.4u ps=1.4u
.ends

.subckt and2_x4 a b y vdd vss
m1 n1 A n2 vss nch w=0.53333u l=0.05u ad=0.05333p as=0.05333p pd=1.26667u ps=1.26667u
m2 n2 B vss vss nch w=0.53333u l=0.05u ad=0.05333p as=0.05333p pd=1.26667u ps=1.26667u
m3 vdd A n1 vdd pch w=0.4u l=0.05u ad=0.04p as=0.04p pd=1u ps=1u
m4 vdd B n1 vdd pch w=0.4u l=0.05u ad=0.04p as=0.04p pd=1u ps=1u
m5 Y n1 vss vss nch w=0.8u l=0.05u ad=0.08p as=0.08p pd=1.8u ps=1.8u
m6 vdd n1 Y vdd pch w=1.2u l=0.05u ad=0.12p as=0.12p pd=2.6u ps=2.6u
.ends

.subckt nor2_x1 a b y vdd vss
m1 Y A vss vss nch w=0.2u l=0.05u ad=0.02p as=0.02p pd=0.6u ps=0.6u
m2 Y B vss vss nch w=0.2u l=0.05u ad=0.02p as=0.02p pd=0.6u ps=0.6u
m3 vdd A n1 vdd pch w=0.6u l=0.05u ad=0.06p as=0.06p pd=1.4u ps=1.4u
m4 n1 B Y vdd pch w=0.6u l=0.05u ad=0.06p as=0.06p pd=1.4u ps=1.4u
.ends

.subckt nor2_x2 a b y vdd vss
m1 Y A vss vss nch w=0.4u l=0.05u ad=0.04p as=0.04p pd=1u ps=1u
m2 Y B vss vss nch w=0.4u l=0.05u ad=0.04p as=0.04p pd=1u ps=1u
m3 vdd A n1 vdd pch w=1.2u l=0.05u ad=0.12p as=0.12p pd=2.6u ps=2.6u
m4 n1 B Y vdd pch w=1.2u l=0.05u ad=0.12p as=0.12p pd=2.6u ps=2.6u
.ends

.subckt nor2_x4 a b y vdd vss
m1 Y A vss vss nch w=0.8u l=0.05u ad=0.08p as=0.08p pd=1.8u ps=1.8u
m2 Y B vss vss nch w=0.8u l=0.05u ad=0.08p as=0.08p pd=1.8u ps=1.8u
m3 vdd A n1 vdd pch w=2.4u l=0.05u ad=0.24p as=0.24p pd=5u ps=5u
m4 n1 B Y vdd pch w=2.4u l=0.05u ad=0.24p as=0.24p pd=5u ps=5u
.ends

.subckt or2_x1 a b y vdd vss
m1 n1 A vss vss nch w=0.2u l=0.05u ad=0.02p as=0.02p pd=0.6u ps=0.6u
m2 n1 B vss vss nch w=0.2u l=0.05u ad=0.02p as=0.02p pd=0.6u ps=0.6u
m3 vdd A n2 vdd pch w=0.6u l=0.05u ad=0.06p as=0.06p pd=1.4u ps=1.4u
m4 n2 B n1 vdd pch w=0.6u l=0.05u ad=0.06p as=0.06p pd=1.4u ps=1.4u
m5 Y n1 vss vss nch w=0.2u l=0.05u ad=0.02p as=0.02p pd=0.6u ps=0.6u
m6 vdd n1 Y vdd pch w=0.3u l=0.05u ad=0.03p as=0.03p pd=0.8u ps=0.8u
.ends

.subckt or2_x2 a b y vdd vss
m1 n1 A vss vss nch w=0.2u l=0.05u ad=0.02p as=0.02p pd=0.6u ps=0.6u
m2 n1 B vss vss nch w=0.2u l=0.05u ad=0.02p as=0.02p pd=0.6u ps=0.6u
m3 vdd A n2 vdd pch w=0.6u l=0.05u ad=0.06p as=0.06p pd=1.4u ps=1.4u
m4 n2 B n1 vdd pch w=0.6u l=0.05u ad=0.06p as=0.06p pd=1.4u ps=1.4u
m5 Y n1 vss vss nch w=0.4u l=0.05u ad=0.04p as=0.04p pd=1u ps=1u
m6 vdd n1 Y vdd pch w=0.6u l=0.05u ad=0.06p as=0.06p pd=1.4u ps=1.4u
.ends

.subckt or2_x4 a b y vdd vss
m1 n1 A vss vss nch w=0.26667u l=0.05u ad=0.02667p as=0.02667p pd=0.73333u ps=0.73333u
m2 n1 B vss vss nch w=0.26667u l=0.05u ad=0.02667p as=0.02667p pd=0.73333u ps=0.73333u
m3 vdd A n2 vdd pch w=0.8u l=0.05u ad=0.08p as=0.08p pd=1.8u ps=1.8u
m4 n2 B n1 vdd pch w=0.8u l=0.05u ad=0.08p as=0.08p pd=1.8u ps=1.8u
m5 Y n1 vss vss nch w=0.8u l=0.05u ad=0.08p as=0.08p pd=1.8u ps=1.8u
m6 vdd n1 Y vdd pch w=1.2u l=0.05u ad=0.12p as=0.12p pd=2.6u ps=2.6u
.ends

.subckt nand3_x1 a b c y vdd vss
m1 Y A n1 vss nch w=0.6u l=0.05u ad=0.06p as=0.06p pd=1.4u ps=1.4u
m2 n1 B n2 vss nch w=0.6u l=0.05u ad=0.06p as=0.06p pd=1.4u ps=1.4u
m3 n2 C vss vss nch w=0.6u l=0.05u ad=0.06p as=0.06p pd=1.4u ps=1.4u
m4 vdd A Y vdd pch w=0.3u l=0.05u ad=0.03p as=0.03p pd=0.8u ps=0.8u
m5 vdd B Y vdd pch w=0.3u l=0.05u ad=0.03p as=0.03p pd=0.8u ps=0.8u
m6 vdd C Y vdd pch w=0.3u l=0.05u ad=0.03p as=0.03p pd=0.8u ps=0.8u
.ends

.subckt nand3_x2 a b c y vdd vss
m1 Y A n1 vss nch w=1.2u l=0.05u ad=0.12p as=0.12p pd=2.6u ps=2.6u
m2 n1 B n2 vss nch w=1.2u l=0.05u ad=0.12p as=0.12p pd=2.6u ps=2.6u
m3 n2 C vss vss nch w=1.2u l=0.05u ad=0.12p as=0.12p pd=2.6u ps=2.6u
m4 vdd A Y vdd pch w=0.6u l=0.05u ad=0.06p as=0.06p pd=1.4u ps=1.4u
m5 vdd B Y vdd pch w=0.6u l=0.05u ad=0.06p as=0.06p pd=1.4u ps=1.4u
m6 vdd C Y vdd pch w=0.6u l=0.05u ad=0.06p as=0.06p pd=1.4u ps=1.4u
.ends

.subckt and3_x1 a b c y vdd vss
m1 n1 A n2 vss nch w=0.6u l=0.05u ad=0.06p as=0.06p pd=1.4u ps=1.4u
m2 n2 B n3 vss nch w=0.6u l=0.05u ad=0.06p as=0.06p pd=1.4u ps=1.4u
m3 n3 C vss vss nch w=0.6u l=0.05u ad=0.06p as=0.06p pd=1.4u ps=1.4u
m4 vdd A n1 vdd pch w=0.3u l=0.05u ad=0.03p as=0.03p pd=0.8u ps=0.8u
m5 vdd B n1 vdd pch w=0.3u l=0.05u ad=0.03p as=0.03p pd=0.8u ps=0.8u
m6 vdd C n1 vdd pch w=0.3u l=0.05u ad=0.03p as=0.03p pd=0.8u ps=0.8u
m7 Y n1 vss vss nch w=0.2u l=0.05u ad=0.02p as=0.02p pd=0.6u ps=0.6u
m8 vdd n1 Y vdd pch w=0.3u l=0.05u ad=0.03p as=0.03p pd=0.8u ps=0.8u
.ends

.subckt and3_x2 a b c y vdd vss
m1 n1 A n2 vss nch w=0.6u l=0.05u ad=0.06p as=0.06p pd=1.4u ps=1.4u
m2 n2 B n3 vss nch w=0.6u l=0.05u ad=0.06p as=0.06p pd=1.4u ps=1.4u
m3 n3 C vss vss nch w=0.6u l=0.05u ad=0.06p as=0.06p pd=1.4u ps=1.4u
m4 vdd A n1 vdd pch w=0.3u l=0.05u ad=0.03p as=0.03p pd=0.8u ps=0.8u
m5 vdd B n1 vdd pch w=0.3u l=0.05u ad=0.03p as=0.03p pd=0.8u ps=0.8u
m6 vdd C n1 vdd pch w=0.3u l=0.05u ad=0.03p as=0.03p pd=0.8u ps=0.8u
m7 Y n1 vss vss nch w=0.4u l=0.05u ad=0.04p as=0.04p pd=1u ps=1u
m8 vdd n1 Y vdd pch w=0.6u l=0.05u ad=0.06p as=0.06p pd=1.4u ps=1.4u
.ends

.subckt nor3_x1 a b c y vdd vss
m1 Y A vss vss nch w=0.2u l=0.05u ad=0.02p as=0.02p pd=0.6u ps=0.6u
m2 Y B vss vss nch w=0.2u l=0.05u ad=0.02p as=0.02p pd=0.6u ps=0.6u
m3 Y C vss vss nch w=0.2u l=0.05u ad=0.02p as=0.02p pd=0.6u ps=0.6u
m4 vdd A n1 vdd pch w=0.9u l=0.05u ad=0.09p as=0.09p pd=2u ps=2u
m5 n1 B n2 vdd pch w=0.9u l=0.05u ad=0.09p as=0.09p pd=2u ps=2u
m6 n2 C Y vdd pch w=0.9u l=0.05u ad=0.09p as=0.09p pd=2u ps=2u
.ends

.subckt nor3_x2 a b c y vdd vss
m1 Y A vss vss nch w=0.4u l=0.05u ad=0.04p as=0.04p pd=1u ps=1u
m2 Y B vss vss nch w=0.4u l=0.05u ad=0.04p as=0.04p pd=1u ps=1u
m3 Y C vss vss nch w=0.4u l=0.05u ad=0.04p as=0.04p pd=1u ps=1u
m4 vdd A n1 vdd pch w=1.8u l=0.05u ad=0.18p as=0.18p pd=3.8u ps=3.8u
m5 n1 B n2 vdd pch w=1.8u l=0.05u ad=0.18p as=0.18p pd=3.8u ps=3.8u
m6 n2 C Y vdd pch w=1.8u l=0.05u ad=0.18p as=0.18p pd=3.8u ps=3.8u
.ends

.subckt or3_x1 a b c y vdd vss
m1 n1 A vss vss nch w=0.2u l=0.05u ad=0.02p as=0.02p pd=0.6u ps=0.6u
m2 n1 B vss vss nch w=0.2u l=0.05u ad=0.02p as=0.02p pd=0.6u ps=0.6u
m3 n1 C vss vss nch w=0.2u l=0.05u ad=0.02p as=0.02p pd=0.6u ps=0.6u
m4 vdd A n2 vdd pch w=0.9u l=0.05u ad=0.09p as=0.09p pd=2u ps=2u
m5 n2 B n3 vdd pch w=0.9u l=0.05u ad=0.09p as=0.09p pd=2u ps=2u
m6 n3 C n1 vdd pch w=0.9u l=0.05u ad=0.09p as=0.09p pd=2u ps=2u
m7 Y n1 vss vss nch w=0.2u l=0.05u ad=0.02p as=0.02p pd=0.6u ps=0.6u
m8 vdd n1 Y vdd pch w=0.3u l=0.05u ad=0.03p as=0.03p pd=0.8u ps=0.8u
.ends

.subckt or3_x2 a b c y vdd vss
m1 n1 A vss vss nch w=0.2u l=0.05u ad=0.02p as=0.02p pd=0.6u ps=0.6u
m2 n1 B vss vss nch w=0.2u l=0.05u ad=0.02p as=0.02p pd=0.6u ps=0.6u
m3 n1 C vss vss nch w=0.2u l=0.05u ad=0.02p as=0.02p pd=0.6u ps=0.6u
m4 vdd A n2 vdd pch w=0.9u l=0.05u ad=0.09p as=0.09p pd=2u ps=2u
m5 n2 B n3 vdd pch w=0.9u l=0.05u ad=0.09p as=0.09p pd=2u ps=2u
m6 n3 C n1 vdd pch w=0.9u l=0.05u ad=0.09p as=0.09p pd=2u ps=2u
m7 Y n1 vss vss nch w=0.4u l=0.05u ad=0.04p as=0.04p pd=1u ps=1u
m8 vdd n1 Y vdd pch w=0.6u l=0.05u ad=0.06p as=0.06p pd=1.4u ps=1.4u
.ends

.subckt nand4_x1 a b c d y vdd vss
m1 Y A n1 vss nch w=0.8u l=0.05u ad=0.08p as=0.08p pd=1.8u ps=1.8u
m2 n1 B n2 vss nch w=0.8u l=0.05u ad=0.08p as=0.08p pd=1.8u ps=1.8u
m3 n2 C n3 vss nch w=0.8u l=0.05u ad=0.08p as=0.08p pd=1.8u ps=1.8u
m4 n3 D vss vss nch w=0.8u l=0.05u ad=0.08p as=0.08p pd=1.8u ps=1.8u
m5 vdd A Y vdd pch w=0.3u l=0.05u ad=0.03p as=0.03p pd=0.8u ps=0.8u
m6 vdd B Y vdd pch w=0.3u l=0.05u ad=0.03p as=0.03p pd=0.8u ps=0.8u
m7 vdd C Y vdd pch w=0.3u l=0.05u ad=0.03p as=0.03p pd=0.8u ps=0.8u
m8 vdd D Y vdd pch w=0.3u l=0.05u ad=0.03p as=0.03p pd=0.8u ps=0.8u
.ends

.subckt nand4_x2 a b c d y vdd vss
m1 Y A n1 vss nch w=1.6u l=0.05u ad=0.16p as=0.16p pd=3.4u ps=3.4u
m2 n1 B n2 vss nch w=1.6u l=0.05u ad=0.16p as=0.16p pd=3.4u ps=3.4u
m3 n2 C n3 vss nch w=1.6u l=0.05u ad=0.16p as=0.16p pd=3.4u ps=3.4u
m4 n3 D vss vss nch w=1.6u l=0.05u ad=0.16p as=0.16p pd=3.4u ps=3.4u
m5 vdd A Y vdd pch w=0.6u l=0.05u ad=0.06p as=0.06p pd=1.4u ps=1.4u
m6 vdd B Y vdd pch w=0.6u l=0.05u ad=0.06p as=0.06p pd=1.4u ps=1.4u
m7 vdd C Y vdd pch w=0.6u l=0.05u ad=0.06p as=0.06p pd=1.4u ps=1.4u
m8 vdd D Y vdd pch w=0.6u l=0.05u ad=0.06p as=0.06p pd=1.4u ps=1.4u
.ends

.subckt and4_x1 a b c d y vdd vss
m1 n1 A n2 vss nch w=0.8u l=0.05u ad=0.08p as=0.08p pd=1.8u ps=1.8u
m2 n2 B n3 vss nch w=0.8u l=0.05u ad=0.08p as=0.08p pd=1.8u ps=1.8u
m3 n3 C n4 vss nch w=0.8u l=0.05u ad=0.08p as=0.08p pd=1.8u ps=1.8u
m4 n4 D vss vss nch w=0.8u l=0.05u ad=0.08p as=0.08p pd=1.8u ps=1.8u
m5 vdd A n1 vdd pch w=0.3u l=0.05u ad=0.03p as=0.03p pd=0.8u ps=0.8u
m6 vdd B n1 vdd pch w=0.3u l=0.05u ad=0.03p as=0.03p pd=0.8u ps=0.8u
m7 vdd C n1 vdd pch w=0.3u l=0.05u ad=0.03p as=0.03p pd=0.8u ps=0.8u
m8 vdd D n1 vdd pch w=0.3u l=0.05u ad=0.03p as=0.03p pd=0.8u ps=0.8u
m9 Y n1 vss vss nch w=0.2u l=0.05u ad=0.02p as=0.02p pd=0.6u ps=0.6u
m10 vdd n1 Y vdd pch w=0.3u l=0.05u ad=0.03p as=0.03p pd=0.8u ps=0.8u
.ends

.subckt and4_x2 a b c d y vdd vss
m1 n1 A n2 vss nch w=0.8u l=0.05u ad=0.08p as=0.08p pd=1.8u ps=1.8u
m2 n2 B n3 vss nch w=0.8u l=0.05u ad=0.08p as=0.08p pd=1.8u ps=1.8u
m3 n3 C n4 vss nch w=0.8u l=0.05u ad=0.08p as=0.08p pd=1.8u ps=1.8u
m4 n4 D vss vss nch w=0.8u l=0.05u ad=0.08p as=0.08p pd=1.8u ps=1.8u
m5 vdd A n1 vdd pch w=0.3u l=0.05u ad=0.03p as=0.03p pd=0.8u ps=0.8u
m6 vdd B n1 vdd pch w=0.3u l=0.05u ad=0.03p as=0.03p pd=0.8u ps=0.8u
m7 vdd C n1 vdd pch w=0.3u l=0.05u ad=0.03p as=0.03p pd=0.8u ps=0.8u
m8 vdd D n1 vdd pch w=0.3u l=0.05u ad=0.03p as=0.03p pd=0.8u ps=0.8u
m9 Y n1 vss vss nch w=0.4u l=0.05u ad=0.04p as=0.04p pd=1u ps=1u
m10 vdd n1 Y vdd pch w=0.6u l=0.05u ad=0.06p as=0.06p pd=1.4u ps=1.4u
.ends

.subckt nor4_x1 a b c d y vdd vss
m1 Y A vss vss nch w=0.2u l=0.05u ad=0.02p as=0.02p pd=0.6u ps=0.6u
m2 Y B vss vss nch w=0.2u l=0.05u ad=0.02p as=0.02p pd=0.6u ps=0.6u
m3 Y C vss vss nch w=0.2u l=0.05u ad=0.02p as=0.02p pd=0.6u ps=0.6u
m4 Y D vss vss nch w=0.2u l=0.05u ad=0.02p as=0.02p pd=0.6u ps=0.6u
m5 vdd A n1 vdd pch w=1.2u l=0.05u ad=0.12p as=0.12p pd=2.6u ps=2.6u
m6 n1 B n2 vdd pch w=1.2u l=0.05u ad=0.12p as=0.12p pd=2.6u ps=2.6u
m7 n2 C n3 vdd pch w=1.2u l=0.05u ad=0.12p as=0.12p pd=2.6u ps=2.6u
m8 n3 D Y vdd pch w=1.2u l=0.05u ad=0.12p as=0.12p pd=2.6u ps=2.6u
.ends

.subckt nor4_x2 a b c d y vdd vss
m1 Y A vss vss nch w=0.4u l=0.05u ad=0.04p as=0.04p pd=1u ps=1u
m2 Y B vss vss nch w=0.4u l=0.05u ad=0.04p as=0.04p pd=1u ps=1u
m3 Y C vss vss nch w=0.4u l=0.05u ad=0.04p as=0.04p pd=1u ps=1u
m4 Y D vss vss nch w=0.4u l=0.05u ad=0.04p as=0.04p pd=1u ps=1u
m5 vdd A n1 vdd pch w=2.4u l=0.05u ad=0.24p as=0.24p pd=5u ps=5u
m6 n1 B n2 vdd pch w=2.4u l=0.05u ad=0.24p as=0.24p pd=5u ps=5u
m7 n2 C n3 vdd pch w=2.4u l=0.05u ad=0.24p as=0.24p pd=5u ps=5u
m8 n3 D Y vdd pch w=2.4u l=0.05u ad=0.24p as=0.24p pd=5u ps=5u
.ends

.subckt or4_x1 a b c d y vdd vss
m1 n1 A vss vss nch w=0.2u l=0.05u ad=0.02p as=0.02p pd=0.6u ps=0.6u
m2 n1 B vss vss nch w=0.2u l=0.05u ad=0.02p as=0.02p pd=0.6u ps=0.6u
m3 n1 C vss vss nch w=0.2u l=0.05u ad=0.02p as=0.02p pd=0.6u ps=0.6u
m4 n1 D vss vss nch w=0.2u l=0.05u ad=0.02p as=0.02p pd=0.6u ps=0.6u
m5 vdd A n2 vdd pch w=1.2u l=0.05u ad=0.12p as=0.12p pd=2.6u ps=2.6u
m6 n2 B n3 vdd pch w=1.2u l=0.05u ad=0.12p as=0.12p pd=2.6u ps=2.6u
m7 n3 C n4 vdd pch w=1.2u l=0.05u ad=0.12p as=0.12p pd=2.6u ps=2.6u
m8 n4 D n1 vdd pch w=1.2u l=0.05u ad=0.12p as=0.12p pd=2.6u ps=2.6u
m9 Y n1 vss vss nch w=0.2u l=0.05u ad=0.02p as=0.02p pd=0.6u ps=0.6u
m10 vdd n1 Y vdd pch w=0.3u l=0.05u ad=0.03p as=0.03p pd=0.8u ps=0.8u
.ends

.subckt or4_x2 a b c d y vdd vss
m1 n1 A vss vss nch w=0.2u l=0.05u ad=0.02p as=0.02p pd=0.6u ps=0.6u
m2 n1 B vss vss nch w=0.2u l=0.05u ad=0.02p as=0.02p pd=0.6u ps=0.6u
m3 n1 C vss vss nch w=0.2u l=0.05u ad=0.02p as=0.02p pd=0.6u ps=0.6u
m4 n1 D vss vss nch w=0.2u l=0.05u ad=0.02p as=0.02p pd=0.6u ps=0.6u
m5 vdd A n2 vdd pch w=1.2u l=0.05u ad=0.12p as=0.12p pd=2.6u ps=2.6u
m6 n2 B n3 vdd pch w=1.2u l=0.05u ad=0.12p as=0.12p pd=2.6u ps=2.6u
m7 n3 C n4 vdd pch w=1.2u l=0.05u ad=0.12p as=0.12p pd=2.6u ps=2.6u
m8 n4 D n1 vdd pch w=1.2u l=0.05u ad=0.12p as=0.12p pd=2.6u ps=2.6u
m9 Y n1 vss vss nch w=0.4u l=0.05u ad=0.04p as=0.04p pd=1u ps=1u
m10 vdd n1 Y vdd pch w=0.6u l=0.05u ad=0.06p as=0.06p pd=1.4u ps=1.4u
.ends

.subckt xor2_x1 a b y vdd vss
m1 n1 A vss vss nch w=0.2u l=0.05u ad=0.02p as=0.02p pd=0.6u ps=0.6u
m2 vdd A n1 vdd pch w=0.3u l=0.05u ad=0.03p as=0.03p pd=0.8u ps=0.8u
m3 n2 B vss vss nch w=0.2u l=0.05u ad=0.02p as=0.02p pd=0.6u ps=0.6u
m4 vdd B n2 vdd pch w=0.3u l=0.05u ad=0.03p as=0.03p pd=0.8u ps=0.8u
m5 n3 A n4 vss nch w=0.4u l=0.05u ad=0.04p as=0.04p pd=1u ps=1u
m6 n4 n2 vss vss nch w=0.4u l=0.05u ad=0.04p as=0.04p pd=1u ps=1u
m7 n3 n1 n5 vss nch w=0.4u l=0.05u ad=0.04p as=0.04p pd=1u ps=1u
m8 n5 B vss vss nch w=0.4u l=0.05u ad=0.04p as=0.04p pd=1u ps=1u
m9 vdd A n6 vdd pch w=0.6u l=0.05u ad=0.06p as=0.06p pd=1.4u ps=1.4u
m10 vdd n2 n6 vdd pch w=0.6u l=0.05u ad=0.06p as=0.06p pd=1.4u ps=1.4u
m11 n6 n1 n3 vdd pch w=0.6u l=0.05u ad=0.06p as=0.06p pd=1.4u ps=1.4u
m12 n6 B n3 vdd pch w=0.6u l=0.05u ad=0.06p as=0.06p pd=1.4u ps=1.4u
m13 Y n3 vss vss nch w=0.2u l=0.05u ad=0.02p as=0.02p pd=0.6u ps=0.6u
m14 vdd n3 Y vdd pch w=0.3u l=0.05u ad=0.03p as=0.03p pd=0.8u ps=0.8u
.ends

.subckt xor2_x2 a b y vdd vss
m1 n1 A vss vss nch w=0.2u l=0.05u ad=0.02p as=0.02p pd=0.6u ps=0.6u
m2 vdd A n1 vdd pch w=0.3u l=0.05u ad=0.03p as=0.03p pd=0.8u ps=0.8u
m3 n2 B vss vss nch w=0.2u l=0.05u ad=0.02p as=0.02p pd=0.6u ps=0.6u
m4 vdd B n2 vdd pch w=0.3u l=0.05u ad=0.03p as=0.03p pd=0.8u ps=0.8u
m5 n3 A n4 vss nch w=0.4u l=0.05u ad=0.04p as=0.04p pd=1u ps=1u
m6 n4 n2 vss vss nch w=0.4u l=0.05u ad=0.04p as=0.04p pd=1u ps=1u
m7 n3 n1 n5 vss nch w=0.4u l=0.05u ad=0.04p as=0.04p pd=1u ps=1u
m8 n5 B vss vss nch w=0.4u l=0.05u ad=0.04p as=0.04p pd=1u ps=1u
m9 vdd A n6 vdd pch w=0.6u l=0.05u ad=0.06p as=0.06p pd=1.4u ps=1.4u
m10 vdd n2 n6 vdd pch w=0.6u l=0.05u ad=0.06p as=0.06p pd=1.4u ps=1.4u
m11 n6 n1 n3 vdd pch w=0.6u l=0.05u ad=0.06p as=0.06p pd=1.4u ps=1.4u
m12 n6 B n3 vdd pch w=0.6u l=0.05u ad=0.06p as=0.06p pd=1.4u ps=1.4u
m13 Y n3 vss vss nch w=0.4u l=0.05u ad=0.04p as=0.04p pd=1u ps=1u
m14 vdd n3 Y vdd pch w=0.6u l=0.05u ad=0.06p as=0.06p pd=1.4u ps=1.4u
.ends

.subckt xnor2_x1 a b y vdd vss
m1 n1 A vss vss nch w=0.2u l=0.05u ad=0.02p as=0.02p pd=0.6u ps=0.6u
m2 vdd A n1 vdd pch w=0.3u l=0.05u ad=0.03p as=0.03p pd=0.8u ps=0.8u
m3 n2 B vss vss nch w=0.2u l=0.05u ad=0.02p as=0.02p pd=0.6u ps=0.6u
m4 vdd B n2 vdd pch w=0.3u l=0.05u ad=0.03p as=0.03p pd=0.8u ps=0.8u
m5 n3 A n4 vss nch w=0.4u l=0.05u ad=0.04p as=0.04p pd=1u ps=1u
m6 n4 B vss vss nch w=0.4u l=0.05u ad=0.04p as=0.04p pd=1u ps=1u
m7 n3 n1 n5 vss nch w=0.4u l=0.05u ad=0.04p as=0.04p pd=1u ps=1u
m8 n5 n2 vss vss nch w=0.4u l=0.05u ad=0.04p as=0.04p pd=1u ps=1u
m9 vdd A n6 vdd pch w=0.6u l=0.05u ad=0.06p as=0.06p pd=1.4u ps=1.4u
m10 vdd B n6 vdd pch w=0.6u l=0.05u ad=0.06p as=0.06p pd=1.4u ps=1.4u
m11 n6 n1 n3 vdd pch w=0.6u l=0.05u ad=0.06p as=0.06p pd=1.4u ps=1.4u
m12 n6 n2 n3 vdd pch w=0.6u l=0.05u ad=0.06p as=0.06p pd=1.4u ps=1.4u
m13 Y n3 vss vss nch w=0.2u l=0.05u ad=0.02p as=0.02p pd=0.6u ps=0.6u
m14 vdd n3 Y vdd pch w=0.3u l=0.05u ad=0.03p as=0.03p pd=0.8u ps=0.8u
.ends

.subckt xnor2_x2 a b y vdd vss
m1 n1 A vss vss nch w=0.2u l=0.05u ad=0.02p as=0.02p pd=0.6u ps=0.6u
m2 vdd A n1 vdd pch w=0.3u l=0.05u ad=0.03p as=0.03p pd=0.8u ps=0.8u
m3 n2 B vss vss nch w=0.2u l=0.05u ad=0.02p as=0.02p pd=0.6u ps=0.6u
m4 vdd B n2 vdd pch w=0.3u l=0.05u ad=0.03p as=0.03p pd=0.8u ps=0.8u
m5 n3 A n4 vss nch w=0.4u l=0.05u ad=0.04p as=0.04p pd=1u ps=1u
m6 n4 B vss vss nch w=0.4u l=0.05u ad=0.04p as=0.04p pd=1u ps=1u
m7 n3 n1 n5 vss nch w=0.4u l=0.05u ad=0.04p as=0.04p pd=1u ps=1u
m8 n5 n2 vss vss nch w=0.4u l=0.05u ad=0.04p as=0.04p pd=1u ps=1u
m9 vdd A n6 vdd pch w=0.6u l=0.05u ad=0.06p as=0.06p pd=1.4u ps=1.4u
m10 vdd B n6 vdd pch w=0.6u l=0.05u ad=0.06p as=0.06p pd=1.4u ps=1.4u
m11 n6 n1 n3 vdd pch w=0.6u l=0.05u ad=0.06p as=0.06p pd=1.4u ps=1.4u
m12 n6 n2 n3 vdd pch w=0.6u l=0.05u ad=0.06p as=0.06p pd=1.4u ps=1.4u
m13 Y n3 vss vss nch w=0.4u l=0.05u ad=0.04p as=0.04p pd=1u ps=1u
m14 vdd n3 Y vdd pch w=0.6u l=0.05u ad=0.06p as=0.06p pd=1.4u ps=1.4u
.ends

.subckt aoi21_x1 a1 a2 b y vdd vss
m1 Y A1 n1 vss nch w=0.4u l=0.05u ad=0.04p as=0.04p pd=1u ps=1u
m2 n1 A2 vss vss nch w=0.4u l=0.05u ad=0.04p as=0.04p pd=1u ps=1u
m3 Y B vss vss nch w=0.2u l=0.05u ad=0.02p as=0.02p pd=0.6u ps=0.6u
m4 vdd A1 n2 vdd pch w=0.6u l=0.05u ad=0.06p as=0.06p pd=1.4u ps=1.4u
m5 vdd A2 n2 vdd pch w=0.6u l=0.05u ad=0.06p as=0.06p pd=1.4u ps=1.4u
m6 n2 B Y vdd pch w=0.6u l=0.05u ad=0.06p as=0.06p pd=1.4u ps=1.4u
.ends

.subckt aoi21_x2 a1 a2 b y vdd vss
m1 Y A1 n1 vss nch w=0.8u l=0.05u ad=0.08p as=0.08p pd=1.8u ps=1.8u
m2 n1 A2 vss vss nch w=0.8u l=0.05u ad=0.08p as=0.08p pd=1.8u ps=1.8u
m3 Y B vss vss nch w=0.4u l=0.05u ad=0.04p as=0.04p pd=1u ps=1u
m4 vdd A1 n2 vdd pch w=1.2u l=0.05u ad=0.12p as=0.12p pd=2.6u ps=2.6u
m5 vdd A2 n2 vdd pch w=1.2u l=0.05u ad=0.12p as=0.12p pd=2.6u ps=2.6u
m6 n2 B Y vdd pch w=1.2u l=0.05u ad=0.12p as=0.12p pd=2.6u ps=2.6u
.ends

.subckt aoi22_x1 a1 a2 b1 b2 y vdd vss
m1 Y A1 n1 vss nch w=0.4u l=0.05u ad=0.04p as=0.04p pd=1u ps=1u
m2 n1 A2 vss vss nch w=0.4u l=0.05u ad=0.04p as=0.04p pd=1u ps=1u
m3 Y B1 n2 vss nch w=0.4u l=0.05u ad=0.04p as=0.04p pd=1u ps=1u
m4 n2 B2 vss vss nch w=0.4u l=0.05u ad=0.04p as=0.04p pd=1u ps=1u
m5 vdd A1 n3 vdd pch w=0.6u l=0.05u ad=0.06p as=0.06p pd=1.4u ps=1.4u
m6 vdd A2 n3 vdd pch w=0.6u l=0.05u ad=0.06p as=0.06p pd=1.4u ps=1.4u
m7 n3 B1 Y vdd pch w=0.6u l=0.05u ad=0.06p as=0.06p pd=1.4u ps=1.4u
m8 n3 B2 Y vdd pch w=0.6u l=0.05u ad=0.06p as=0.06p pd=1.4u ps=1.4u
.ends

.subckt aoi22_x2 a1 a2 b1 b2 y vdd vss
m1 Y A1 n1 vss nch w=0.8u l=0.05u ad=0.08p as=0.08p pd=1.8u ps=1.8u
m2 n1 A2 vss vss nch w=0.8u l=0.05u ad=0.08p as=0.08p pd=1.8u ps=1.8u
m3 Y B1 n2 vss nch w=0.8u l=0.05u ad=0.08p as=0.08p pd=1.8u ps=1.8u
m4 n2 B2 vss vss nch w=0.8u l=0.05u ad=0.08p as=0.08p pd=1.8u ps=1.8u
m5 vdd A1 n3 vdd pch w=1.2u l=0.05u ad=0.12p as=0.12p pd=2.6u ps=2.6u
m6 vdd A2 n3 vdd pch w=1.2u l=0.05u ad=0.12p as=0.12p pd=2.6u ps=2.6u
m7 n3 B1 Y vdd pch w=1.2u l=0.05u ad=0.12p as=0.12p pd=2.6u ps=2.6u
m8 n3 B2 Y vdd pch w=1.2u l=0.05u ad=0.12p as=0.12p pd=2.6u ps=2.6u
.ends

.subckt aoi211_x1 a1 a2 b c y vdd vss
m1 Y A1 n1 vss nch w=0.4u l=0.05u ad=0.04p as=0.04p pd=1u ps=1u
m2 n1 A2 vss vss nch w=0.4u l=0.05u ad=0.04p as=0.04p pd=1u ps=1u
m3 Y B vss vss nch w=0.2u l=0.05u ad=0.02p as=0.02p pd=0.6u ps=0.6u
m4 Y C vss vss nch w=0.2u l=0.05u ad=0.02p as=0.02p pd=0.6u ps=0.6u
m5 vdd A1 n2 vdd pch w=0.9u l=0.05u ad=0.09p as=0.09p pd=2u ps=2u
m6 vdd A2 n2 vdd pch w=0.9u l=0.05u ad=0.09p as=0.09p pd=2u ps=2u
m7 n2 B n3 vdd pch w=0.9u l=0.05u ad=0.09p as=0.09p pd=2u ps=2u
m8 n3 C Y vdd pch w=0.9u l=0.05u ad=0.09p as=0.09p pd=2u ps=2u
.ends

.subckt oai21_x1 a1 a2 b y vdd vss
m1 Y A1 n1 vss nch w=0.4u l=0.05u ad=0.04p as=0.04p pd=1u ps=1u
m2 Y A2 n1 vss nch w=0.4u l=0.05u ad=0.04p as=0.04p pd=1u ps=1u
m3 n1 B vss vss nch w=0.4u l=0.05u ad=0.04p as=0.04p pd=1u ps=1u
m4 vdd A1 n2 vdd pch w=0.6u l=0.05u ad=0.06p as=0.06p pd=1.4u ps=1.4u
m5 n2 A2 Y vdd pch w=0.6u l=0.05u ad=0.06p as=0.06p pd=1.4u ps=1.4u
m6 vdd B Y vdd pch w=0.3u l=0.05u ad=0.03p as=0.03p pd=0.8u ps=0.8u
.ends

.subckt oai21_x2 a1 a2 b y vdd vss
m1 Y A1 n1 vss nch w=0.8u l=0.05u ad=0.08p as=0.08p pd=1.8u ps=1.8u
m2 Y A2 n1 vss nch w=0.8u l=0.05u ad=0.08p as=0.08p pd=1.8u ps=1.8u
m3 n1 B vss vss nch w=0.8u l=0.05u ad=0.08p as=0.08p pd=1.8u ps=1.8u
m4 vdd A1 n2 vdd pch w=1.2u l=0.05u ad=0.12p as=0.12p pd=2.6u ps=2.6u
m5 n2 A2 Y vdd pch w=1.2u l=0.05u ad=0.12p as=0.12p pd=2.6u ps=2.6u
m6 vdd B Y vdd pch w=0.6u l=0.05u ad=0.06p as=0.06p pd=1.4u ps=1.4u
.ends

.subckt oai22_x1 a1 a2 b1 b2 y vdd vss
m1 Y A1 n1 vss nch w=0.4u l=0.05u ad=0.04p as=0.04p pd=1u ps=1u
m2 Y A2 n1 vss nch w=0.4u l=0.05u ad=0.04p as=0.04p pd=1u ps=1u
m3 n1 B1 vss vss nch w=0.4u l=0.05u ad=0.04p as=0.04p pd=1u ps=1u
m4 n1 B2 vss vss nch w=0.4u l=0.05u ad=0.04p as=0.04p pd=1u ps=1u
m5 vdd A1 n2 vdd pch w=0.6u l=0.05u ad=0.06p as=0.06p pd=1.4u ps=1.4u
m6 n2 A2 Y vdd pch w=0.6u l=0.05u ad=0.06p as=0.06p pd=1.4u ps=1.4u
m7 vdd B1 n3 vdd pch w=0.6u l=0.05u ad=0.06p as=0.06p pd=1.4u ps=1.4u
m8 n3 B2 Y vdd pch w=0.6u l=0.05u ad=0.06p as=0.06p pd=1.4u ps=1.4u
.ends

.subckt oai22_x2 a1 a2 b1 b2 y vdd vss
m1 Y A1 n1 vss nch w=0.8u l=0.05u ad=0.08p as=0.08p pd=1.8u ps=1.8u
m2 Y A2 n1 vss nch w=0.8u l=0.05u ad=0.08p as=0.08p pd=1.8u ps=1.8u
m3 n1 B1 vss vss nch w=0.8u l=0.05u ad=0.08p as=0.08p pd=1.8u ps=1.8u
m4 n1 B2 vss vss nch w=0.8u l=0.05u ad=0.08p as=0.08p pd=1.8u ps=1.8u
m5 vdd A1 n2 vdd pch w=1.2u l=0.05u ad=0.12p as=0.12p pd=2.6u ps=2.6u
m6 n2 A2 Y vdd pch w=1.2u l=0.05u ad=0.12p as=0.12p pd=2.6u ps=2.6u
m7 vdd B1 n3 vdd pch w=1.2u l=0.05u ad=0.12p as=0.12p pd=2.6u ps=2.6u
m8 n3 B2 Y vdd pch w=1.2u l=0.05u ad=0.12p as=0.12p pd=2.6u ps=2.6u
.ends

.subckt oai211_x1 a1 a2 b c y vdd vss
m1 Y A1 n1 vss nch w=0.6u l=0.05u ad=0.06p as=0.06p pd=1.4u ps=1.4u
m2 Y A2 n1 vss nch w=0.6u l=0.05u ad=0.06p as=0.06p pd=1.4u ps=1.4u
m3 n1 B n2 vss nch w=0.6u l=0.05u ad=0.06p as=0.06p pd=1.4u ps=1.4u
m4 n2 C vss vss nch w=0.6u l=0.05u ad=0.06p as=0.06p pd=1.4u ps=1.4u
m5 vdd A1 n3 vdd pch w=0.6u l=0.05u ad=0.06p as=0.06p pd=1.4u ps=1.4u
m6 n3 A2 Y vdd pch w=0.6u l=0.05u ad=0.06p as=0.06p pd=1.4u ps=1.4u
m7 vdd B Y vdd pch w=0.3u l=0.05u ad=0.03p as=0.03p pd=0.8u ps=0.8u
m8 vdd C Y vdd pch w=0.3u l=0.05u ad=0.03p as=0.03p pd=0.8u ps=0.8u
.ends

.subckt mux2_x1 a b s y vdd vss
m1 n1 S vss vss nch w=0.2u l=0.05u ad=0.02p as=0.02p pd=0.6u ps=0.6u
m2 vdd S n1 vdd pch w=0.3u l=0.05u ad=0.03p as=0.03p pd=0.8u ps=0.8u
m3 n2 A n3 vss nch w=0.4u l=0.05u ad=0.04p as=0.04p pd=1u ps=1u
m4 n3 n1 vss vss nch w=0.4u l=0.05u ad=0.04p as=0.04p pd=1u ps=1u
m5 n2 B n4 vss nch w=0.4u l=0.05u ad=0.04p as=0.04p pd=1u ps=1u
m6 n4 S vss vss nch w=0.4u l=0.05u ad=0.04p as=0.04p pd=1u ps=1u
m7 vdd A n5 vdd pch w=0.6u l=0.05u ad=0.06p as=0.06p pd=1.4u ps=1.4u
m8 vdd n1 n5 vdd pch w=0.6u l=0.05u ad=0.06p as=0.06p pd=1.4u ps=1.4u
m9 n5 B n2 vdd pch w=0.6u l=0.05u ad=0.06p as=0.06p pd=1.4u ps=1.4u
m10 n5 S n2 vdd pch w=0.6u l=0.05u ad=0.06p as=0.06p pd=1.4u ps=1.4u
m11 Y n2 vss vss nch w=0.2u l=0.05u ad=0.02p as=0.02p pd=0.6u ps=0.6u
m12 vdd n2 Y vdd pch w=0.3u l=0.05u ad=0.03p as=0.03p pd=0.8u ps=0.8u
.ends

.subckt mux2_x2 a b s y vdd vss
m1 n1 S vss vss nch w=0.2u l=0.05u ad=0.02p as=0.02p pd=0.6u ps=0.6u
m2 vdd S n1 vdd pch w=0.3u l=0.05u ad=0.03p as=0.03p pd=0.8u ps=0.8u
m3 n2 A n3 vss nch w=0.4u l=0.05u ad=0.04p as=0.04p pd=1u ps=1u
m4 n3 n1 vss vss nch w=0.4u l=0.05u ad=0.04p as=0.04p pd=1u ps=1u
m5 n2 B n4 vss nch w=0.4u l=0.05u ad=0.04p as=0.04p pd=1u ps=1u
m6 n4 S vss vss nch w=0.4u l=0.05u ad=0.04p as=0.04p pd=1u ps=1u
m7 vdd A n5 vdd pch w=0.6u l=0.05u ad=0.06p as=0.06p pd=1.4u ps=1.4u
m8 vdd n1 n5 vdd pch w=0.6u l=0.05u ad=0.06p as=0.06p pd=1.4u ps=1.4u
m9 n5 B n2 vdd pch w=0.6u l=0.05u ad=0.06p as=0.06p pd=1.4u ps=1.4u
m10 n5 S n2 vdd pch w=0.6u l=0.05u ad=0.06p as=0.06p pd=1.4u ps=1.4u
m11 Y n2 vss vss nch w=0.4u l=0.05u ad=0.04p as=0.04p pd=1u ps=1u
m12 vdd n2 Y vdd pch w=0.6u l=0.05u ad=0.06p as=0.06p pd=1.4u ps=1.4u
.ends

.subckt mux4_x1 a b c d s0 s1 y vdd vss
m1 n1 S0 vss vss nch w=0.2u l=0.05u ad=0.02p as=0.02p pd=0.6u ps=0.6u
m2 vdd S0 n1 vdd pch w=0.3u l=0.05u ad=0.03p as=0.03p pd=0.8u ps=0.8u
m3 n2 S1 vss vss nch w=0.2u l=0.05u ad=0.02p as=0.02p pd=0.6u ps=0.6u
m4 vdd S1 n2 vdd pch w=0.3u l=0.05u ad=0.03p as=0.03p pd=0.8u ps=0.8u
m5 n3 A n4 vss nch w=0.4u l=0.05u ad=0.04p as=0.04p pd=1u ps=1u
m6 n4 n1 vss vss nch w=0.4u l=0.05u ad=0.04p as=0.04p pd=1u ps=1u
m7 n3 B n5 vss nch w=0.4u l=0.05u ad=0.04p as=0.04p pd=1u ps=1u
m8 n5 S0 vss vss nch w=0.4u l=0.05u ad=0.04p as=0.04p pd=1u ps=1u
m9 vdd A n6 vdd pch w=0.6u l=0.05u ad=0.06p as=0.06p pd=1.4u ps=1.4u
m10 vdd n1 n6 vdd pch w=0.6u l=0.05u ad=0.06p as=0.06p pd=1.4u ps=1.4u
m11 n6 B n3 vdd pch w=0.6u l=0.05u ad=0.06p as=0.06p pd=1.4u ps=1.4u
m12 n6 S0 n3 vdd pch w=0.6u l=0.05u ad=0.06p as=0.06p pd=1.4u ps=1.4u
m13 n7 C n8 vss nch w=0.4u l=0.05u ad=0.04p as=0.04p pd=1u ps=1u
m14 n8 n1 vss vss nch w=0.4u l=0.05u ad=0.04p as=0.04p pd=1u ps=1u
m15 n7 D n9 vss nch w=0.4u l=0.05u ad=0.04p as=0.04p pd=1u ps=1u
m16 n9 S0 vss vss nch w=0.4u l=0.05u ad=0.04p as=0.04p pd=1u ps=1u
m17 vdd C n10 vdd pch w=0.6u l=0.05u ad=0.06p as=0.06p pd=1.4u ps=1.4u
m18 vdd n1 n10 vdd pch w=0.6u l=0.05u ad=0.06p as=0.06p pd=1.4u ps=1.4u
m19 n10 D n7 vdd pch w=0.6u l=0.05u ad=0.06p as=0.06p pd=1.4u ps=1.4u
m20 n10 S0 n7 vdd pch w=0.6u l=0.05u ad=0.06p as=0.06p pd=1.4u ps=1.4u
m21 n11 n3 n12 vss nch w=0.4u l=0.05u ad=0.04p as=0.04p pd=1u ps=1u
m22 n12 n2 vss vss nch w=0.4u l=0.05u ad=0.04p as=0.04p pd=1u ps=1u
m23 n11 n7 n13 vss nch w=0.4u l=0.05u ad=0.04p as=0.04p pd=1u ps=1u
m24 n13 S1 vss vss nch w=0.4u l=0.05u ad=0.04p as=0.04p pd=1u ps=1u
m25 vdd n3 n14 vdd pch w=0.6u l=0.05u ad=0.06p as=0.06p pd=1.4u ps=1.4u
m26 vdd n2 n14 vdd pch w=0.6u l=0.05u ad=0.06p as=0.06p pd=1.4u ps=1.4u
m27 n14 n7 n11 vdd pch w=0.6u l=0.05u ad=0.06p as=0.06p pd=1.4u ps=1.4u
m28 n14 S1 n11 vdd pch w=0.6u l=0.05u ad=0.06p as=0.06p pd=1.4u ps=1.4u
m29 n15 n11 vss vss nch w=0.2u l=0.05u ad=0.02p as=0.02p pd=0.6u ps=0.6u
m30 vdd n11 n15 vdd pch w=0.3u l=0.05u ad=0.03p as=0.03p pd=0.8u ps=0.8u
m31 Y n15 vss vss nch w=0.2u l=0.05u ad=0.02p as=0.02p pd=0.6u ps=0.6u
m32 vdd n15 Y vdd pch w=0.3u l=0.05u ad=0.03p as=0.03p pd=0.8u ps=0.8u
.ends

.subckt ha_x1 a b s co vdd vss
m1 n1 A vss vss nch w=0.2u l=0.05u ad=0.02p as=0.02p pd=0.6u ps=0.6u
m2 vdd A n1 vdd pch w=0.3u l=0.05u ad=0.03p as=0.03p pd=0.8u ps=0.8u
m3 n2 B vss vss nch w=0.2u l=0.05u ad=0.02p as=0.02p pd=0.6u ps=0.6u
m4 vdd B n2 vdd pch w=0.3u l=0.05u ad=0.03p as=0.03p pd=0.8u ps=0.8u
m5 n3 A n4 vss nch w=0.4u l=0.05u ad=0.04p as=0.04p pd=1u ps=1u
m6 n4 n2 vss vss nch w=0.4u l=0.05u ad=0.04p as=0.04p pd=1u ps=1u
m7 n3 n1 n5 vss nch w=0.4u l=0.05u ad=0.04p as=0.04p pd=1u ps=1u
m8 n5 B vss vss nch w=0.4u l=0.05u ad=0.04p as=0.04p pd=1u ps=1u
m9 vdd A n6 vdd pch w=0.6u l=0.05u ad=0.06p as=0.06p pd=1.4u ps=1.4u
m10 vdd n2 n6 vdd pch w=0.6u l=0.05u ad=0.06p as=0.06p pd=1.4u ps=1.4u
m11 n6 n1 n3 vdd pch w=0.6u l=0.05u ad=0.06p as=0.06p pd=1.4u ps=1.4u
m12 n6 B n3 vdd pch w=0.6u l=0.05u ad=0.06p as=0.06p pd=1.4u ps=1.4u
m13 S n3 vss vss nch w=0.2u l=0.05u ad=0.02p as=0.02p pd=0.6u ps=0.6u
m14 vdd n3 S vdd pch w=0.3u l=0.05u ad=0.03p as=0.03p pd=0.8u ps=0.8u
m15 n7 A n8 vss nch w=0.4u l=0.05u ad=0.04p as=0.04p pd=1u ps=1u
m16 n8 B vss vss nch w=0.4u l=0.05u ad=0.04p as=0.04p pd=1u ps=1u
m17 vdd A n7 vdd pch w=0.3u l=0.05u ad=0.03p as=0.03p pd=0.8u ps=0.8u
m18 vdd B n7 vdd pch w=0.3u l=0.05u ad=0.03p as=0.03p pd=0.8u ps=0.8u
m19 CO n7 vss vss nch w=0.2u l=0.05u ad=0.02p as=0.02p pd=0.6u ps=0.6u
m20 vdd n7 CO vdd pch w=0.3u l=0.05u ad=0.03p as=0.03p pd=0.8u ps=0.8u
.ends

.subckt fa_x1 a b ci s co vdd vss
m1 n1 A n2 vss nch w=0.4u l=0.05u ad=0.04p as=0.04p pd=1u ps=1u
m2 n2 B vss vss nch w=0.4u l=0.05u ad=0.04p as=0.04p pd=1u ps=1u
m3 n1 CI n3 vss nch w=0.4u l=0.05u ad=0.04p as=0.04p pd=1u ps=1u
m4 n3 A vss vss nch w=0.4u l=0.05u ad=0.04p as=0.04p pd=1u ps=1u
m5 n3 B vss vss nch w=0.4u l=0.05u ad=0.04p as=0.04p pd=1u ps=1u
m6 vdd A n4 vdd pch w=0.6u l=0.05u ad=0.06p as=0.06p pd=1.4u ps=1.4u
m7 vdd B n4 vdd pch w=0.6u l=0.05u ad=0.06p as=0.06p pd=1.4u ps=1.4u
m8 n4 CI n1 vdd pch w=0.6u l=0.05u ad=0.06p as=0.06p pd=1.4u ps=1.4u
m9 n4 A n5 vdd pch w=1.2u l=0.05u ad=0.12p as=0.12p pd=2.6u ps=2.6u
m10 n5 B n1 vdd pch w=1.2u l=0.05u ad=0.12p as=0.12p pd=2.6u ps=2.6u
m11 n6 A n7 vss nch w=0.6u l=0.05u ad=0.06p as=0.06p pd=1.4u ps=1.4u
m12 n7 B n8 vss nch w=0.6u l=0.05u ad=0.06p as=0.06p pd=1.4u ps=1.4u
m13 n8 CI vss vss nch w=0.6u l=0.05u ad=0.06p as=0.06p pd=1.4u ps=1.4u
m14 n6 n1 n9 vss nch w=0.4u l=0.05u ad=0.04p as=0.04p pd=1u ps=1u
m15 n9 A vss vss nch w=0.4u l=0.05u ad=0.04p as=0.04p pd=1u ps=1u
m16 n9 B vss vss nch w=0.4u l=0.05u ad=0.04p as=0.04p pd=1u ps=1u
m17 n9 CI vss vss nch w=0.4u l=0.05u ad=0.04p as=0.04p pd=1u ps=1u
m18 vdd A n10 vdd pch w=0.6u l=0.05u ad=0.06p as=0.06p pd=1.4u ps=1.4u
m19 vdd B n10 vdd pch w=0.6u l=0.05u ad=0.06p as=0.06p pd=1.4u ps=1.4u
m20 vdd CI n10 vdd pch w=0.6u l=0.05u ad=0.06p as=0.06p pd=1.4u ps=1.4u
m21 n10 n1 n6 vdd pch w=0.6u l=0.05u ad=0.06p as=0.06p pd=1.4u ps=1.4u
m22 n10 A n11 vdd pch w=1.8u l=0.05u ad=0.18p as=0.18p pd=3.8u ps=3.8u
m23 n11 B n12 vdd pch w=1.8u l=0.05u ad=0.18p as=0.18p pd=3.8u ps=3.8u
m24 n12 CI n6 vdd pch w=1.8u l=0.05u ad=0.18p as=0.18p pd=3.8u ps=3.8u
m25 CO n1 vss vss nch w=0.2u l=0.05u ad=0.02p as=0.02p pd=0.6u ps=0.6u
m26 vdd n1 CO vdd pch w=0.3u l=0.05u ad=0.03p as=0.03p pd=0.8u ps=0.8u
m27 S n6 vss vss nch w=0.2u l=0.05u ad=0.02p as=0.02p pd=0.6u ps=0.6u
m28 vdd n6 S vdd pch w=0.3u l=0.05u ad=0.03p as=0.03p pd=0.8u ps=0.8u
.ends

.subckt tbuf_x1 a en y vdd vss
m1 n1 EN vss vss nch w=0.2u l=0.05u ad=0.02p as=0.02p pd=0.6u ps=0.6u
m2 vdd EN n1 vdd pch w=0.3u l=0.05u ad=0.03p as=0.03p pd=0.8u ps=0.8u
m3 n2 A n3 vss nch w=0.4u l=0.05u ad=0.04p as=0.04p pd=1u ps=1u
m4 n3 EN vss vss nch w=0.4u l=0.05u ad=0.04p as=0.04p pd=1u ps=1u
m5 vdd A n2 vdd pch w=0.3u l=0.05u ad=0.03p as=0.03p pd=0.8u ps=0.8u
m6 vdd EN n2 vdd pch w=0.3u l=0.05u ad=0.03p as=0.03p pd=0.8u ps=0.8u
m7 n4 A vss vss nch w=0.2u l=0.05u ad=0.02p as=0.02p pd=0.6u ps=0.6u
m8 n4 n1 vss vss nch w=0.2u l=0.05u ad=0.02p as=0.02p pd=0.6u ps=0.6u
m9 vdd A n5 vdd pch w=0.6u l=0.05u ad=0.06p as=0.06p pd=1.4u ps=1.4u
m10 n5 n1 n4 vdd pch w=0.6u l=0.05u ad=0.06p as=0.06p pd=1.4u ps=1.4u
m11 Y n2 vdd vdd pch w=0.3u l=0.05u ad=0.03p as=0.03p pd=0.8u ps=0.8u
m12 Y n4 vss vss nch w=0.2u l=0.05u ad=0.02p as=0.02p pd=0.6u ps=0.6u
.ends

.subckt tbuf_x2 a en y vdd vss
m1 n1 EN vss vss nch w=0.2u l=0.05u ad=0.02p as=0.02p pd=0.6u ps=0.6u
m2 vdd EN n1 vdd pch w=0.3u l=0.05u ad=0.03p as=0.03p pd=0.8u ps=0.8u
m3 n2 A n3 vss nch w=0.4u l=0.05u ad=0.04p as=0.04p pd=1u ps=1u
m4 n3 EN vss vss nch w=0.4u l=0.05u ad=0.04p as=0.04p pd=1u ps=1u
m5 vdd A n2 vdd pch w=0.3u l=0.05u ad=0.03p as=0.03p pd=0.8u ps=0.8u
m6 vdd EN n2 vdd pch w=0.3u l=0.05u ad=0.03p as=0.03p pd=0.8u ps=0.8u
m7 n4 A vss vss nch w=0.2u l=0.05u ad=0.02p as=0.02p pd=0.6u ps=0.6u
m8 n4 n1 vss vss nch w=0.2u l=0.05u ad=0.02p as=0.02p pd=0.6u ps=0.6u
m9 vdd A n5 vdd pch w=0.6u l=0.05u ad=0.06p as=0.06p pd=1.4u ps=1.4u
m10 n5 n1 n4 vdd pch w=0.6u l=0.05u ad=0.06p as=0.06p pd=1.4u ps=1.4u
m11 Y n2 vdd vdd pch w=0.6u l=0.05u ad=0.06p as=0.06p pd=1.4u ps=1.4u
m12 Y n4 vss vss nch w=0.4u l=0.05u ad=0.04p as=0.04p pd=1u ps=1u
.ends

.subckt dff_x1 d ck q qn vdd vss
m1 n2 CK vss vss nch w=0.2u l=0.05u ad=0.02p as=0.02p pd=0.6u ps=0.6u
m2 vdd CK n2 vdd pch w=0.3u l=0.05u ad=0.03p as=0.03p pd=0.8u ps=0.8u
m3 n3 n2 vss vss nch w=0.2u l=0.05u ad=0.02p as=0.02p pd=0.6u ps=0.6u
m4 vdd n2 n3 vdd pch w=0.3u l=0.05u ad=0.03p as=0.03p pd=0.8u ps=0.8u
m5 D n2 n4 vss nch w=0.2u l=0.05u ad=0.02p as=0.02p pd=0.6u ps=0.6u
m6 D n3 n4 vdd pch w=0.3u l=0.05u ad=0.03p as=0.03p pd=0.8u ps=0.8u
m7 n5 n4 vss vss nch w=0.2u l=0.05u ad=0.02p as=0.02p pd=0.6u ps=0.6u
m8 vdd n4 n5 vdd pch w=0.3u l=0.05u ad=0.03p as=0.03p pd=0.8u ps=0.8u
m9 n4 n3 n7 vss nch w=0.2u l=0.05u ad=0.02p as=0.02p pd=0.6u ps=0.6u
m10 n7 n5 vss vss nch w=0.2u l=0.05u ad=0.02p as=0.02p pd=0.6u ps=0.6u
m11 n4 n2 n8 vdd pch w=0.3u l=0.05u ad=0.03p as=0.03p pd=0.8u ps=0.8u
m12 n8 n5 vdd vdd pch w=0.3u l=0.05u ad=0.03p as=0.03p pd=0.8u ps=0.8u
m13 n5 n3 n6 vss nch w=0.2u l=0.05u ad=0.02p as=0.02p pd=0.6u ps=0.6u
m14 n5 n2 n6 vdd pch w=0.3u l=0.05u ad=0.03p as=0.03p pd=0.8u ps=0.8u
m15 n1 n6 vss vss nch w=0.2u l=0.05u ad=0.02p as=0.02p pd=0.6u ps=0.6u
m16 vdd n6 n1 vdd pch w=0.3u l=0.05u ad=0.03p as=0.03p pd=0.8u ps=0.8u
m17 n6 n2 n9 vss nch w=0.2u l=0.05u ad=0.02p as=0.02p pd=0.6u ps=0.6u
m18 n9 n1 vss vss nch w=0.2u l=0.05u ad=0.02p as=0.02p pd=0.6u ps=0.6u
m19 n6 n3 n10 vdd pch w=0.3u l=0.05u ad=0.03p as=0.03p pd=0.8u ps=0.8u
m20 n10 n1 vdd vdd pch w=0.3u l=0.05u ad=0.03p as=0.03p pd=0.8u ps=0.8u
m21 Q n6 vss vss nch w=0.2u l=0.05u ad=0.02p as=0.02p pd=0.6u ps=0.6u
m22 vdd n6 Q vdd pch w=0.3u l=0.05u ad=0.03p as=0.03p pd=0.8u ps=0.8u
m23 QN n1 vss vss nch w=0.2u l=0.05u ad=0.02p as=0.02p pd=0.6u ps=0.6u
m24 vdd n1 QN vdd pch w=0.3u l=0.05u ad=0.03p as=0.03p pd=0.8u ps=0.8u
.ends

.subckt dff_x2 d ck q qn vdd vss
m1 n2 CK vss vss nch w=0.2u l=0.05u ad=0.02p as=0.02p pd=0.6u ps=0.6u
m2 vdd CK n2 vdd pch w=0.3u l=0.05u ad=0.03p as=0.03p pd=0.8u ps=0.8u
m3 n3 n2 vss vss nch w=0.2u l=0.05u ad=0.02p as=0.02p pd=0.6u ps=0.6u
m4 vdd n2 n3 vdd pch w=0.3u l=0.05u ad=0.03p as=0.03p pd=0.8u ps=0.8u
m5 D n2 n4 vss nch w=0.2u l=0.05u ad=0.02p as=0.02p pd=0.6u ps=0.6u
m6 D n3 n4 vdd pch w=0.3u l=0.05u ad=0.03p as=0.03p pd=0.8u ps=0.8u
m7 n5 n4 vss vss nch w=0.2u l=0.05u ad=0.02p as=0.02p pd=0.6u ps=0.6u
m8 vdd n4 n5 vdd pch w=0.3u l=0.05u ad=0.03p as=0.03p pd=0.8u ps=0.8u
m9 n4 n3 n7 vss nch w=0.2u l=0.05u ad=0.02p as=0.02p pd=0.6u ps=0.6u
m10 n7 n5 vss vss nch w=0.2u l=0.05u ad=0.02p as=0.02p pd=0.6u ps=0.6u
m11 n4 n2 n8 vdd pch w=0.3u l=0.05u ad=0.03p as=0.03p pd=0.8u ps=0.8u
m12 n8 n5 vdd vdd pch w=0.3u l=0.05u ad=0.03p as=0.03p pd=0.8u ps=0.8u
m13 n5 n3 n6 vss nch w=0.2u l=0.05u ad=0.02p as=0.02p pd=0.6u ps=0.6u
m14 n5 n2 n6 vdd pch w=0.3u l=0.05u ad=0.03p as=0.03p pd=0.8u ps=0.8u
m15 n1 n6 vss vss nch w=0.2u l=0.05u ad=0.02p as=0.02p pd=0.6u ps=0.6u
m16 vdd n6 n1 vdd pch w=0.3u l=0.05u ad=0.03p as=0.03p pd=0.8u ps=0.8u
m17 n6 n2 n9 vss nch w=0.2u l=0.05u ad=0.02p as=0.02p pd=0.6u ps=0.6u
m18 n9 n1 vss vss nch w=0.2u l=0.05u ad=0.02p as=0.02p pd=0.6u ps=0.6u
m19 n6 n3 n10 vdd pch w=0.3u l=0.05u ad=0.03p as=0.03p pd=0.8u ps=0.8u
m20 n10 n1 vdd vdd pch w=0.3u l=0.05u ad=0.03p as=0.03p pd=0.8u ps=0.8u
m21 Q n6 vss vss nch w=0.4u l=0.05u ad=0.04p as=0.04p pd=1u ps=1u
m22 vdd n6 Q vdd pch w=0.6u l=0.05u ad=0.06p as=0.06p pd=1.4u ps=1.4u
m23 QN n1 vss vss nch w=0.4u l=0.05u ad=0.04p as=0.04p pd=1u ps=1u
m24 vdd n1 QN vdd pch w=0.6u l=0.05u ad=0.06p as=0.06p pd=1.4u ps=1.4u
.ends

.subckt dffr_x1 d ck rn q qn vdd vss
m1 n2 CK vss vss nch w=0.2u l=0.05u ad=0.02p as=0.02p pd=0.6u ps=0.6u
m2 vdd CK n2 vdd pch w=0.3u l=0.05u ad=0.03p as=0.03p pd=0.8u ps=0.8u
m3 n3 n2 vss vss nch w=0.2u l=0.05u ad=0.02p as=0.02p pd=0.6u ps=0.6u
m4 vdd n2 n3 vdd pch w=0.3u l=0.05u ad=0.03p as=0.03p pd=0.8u ps=0.8u
m5 n7 RN vss vss nch w=0.2u l=0.05u ad=0.02p as=0.02p pd=0.6u ps=0.6u
m6 vdd RN n7 vdd pch w=0.3u l=0.05u ad=0.03p as=0.03p pd=0.8u ps=0.8u
m7 D n2 n4 vss nch w=0.2u l=0.05u ad=0.02p as=0.02p pd=0.6u ps=0.6u
m8 D n3 n4 vdd pch w=0.3u l=0.05u ad=0.03p as=0.03p pd=0.8u ps=0.8u
m9 n5 n4 n8 vss nch w=0.4u l=0.05u ad=0.04p as=0.04p pd=1u ps=1u
m10 n8 RN vss vss nch w=0.4u l=0.05u ad=0.04p as=0.04p pd=1u ps=1u
m11 vdd n4 n5 vdd pch w=0.3u l=0.05u ad=0.03p as=0.03p pd=0.8u ps=0.8u
m12 vdd RN n5 vdd pch w=0.3u l=0.05u ad=0.03p as=0.03p pd=0.8u ps=0.8u
m13 n4 n3 n9 vss nch w=0.2u l=0.05u ad=0.02p as=0.02p pd=0.6u ps=0.6u
m14 n9 n5 vss vss nch w=0.2u l=0.05u ad=0.02p as=0.02p pd=0.6u ps=0.6u
m15 n4 n2 n10 vdd pch w=0.3u l=0.05u ad=0.03p as=0.03p pd=0.8u ps=0.8u
m16 n10 n5 vdd vdd pch w=0.3u l=0.05u ad=0.03p as=0.03p pd=0.8u ps=0.8u
m17 n5 n3 n6 vss nch w=0.2u l=0.05u ad=0.02p as=0.02p pd=0.6u ps=0.6u
m18 n5 n2 n6 vdd pch w=0.3u l=0.05u ad=0.03p as=0.03p pd=0.8u ps=0.8u
m19 n1 n6 vss vss nch w=0.2u l=0.05u ad=0.02p as=0.02p pd=0.6u ps=0.6u
m20 n1 n7 vss vss nch w=0.2u l=0.05u ad=0.02p as=0.02p pd=0.6u ps=0.6u
m21 vdd n6 n11 vdd pch w=0.6u l=0.05u ad=0.06p as=0.06p pd=1.4u ps=1.4u
m22 n11 n7 n1 vdd pch w=0.6u l=0.05u ad=0.06p as=0.06p pd=1.4u ps=1.4u
m23 n6 n2 n12 vss nch w=0.2u l=0.05u ad=0.02p as=0.02p pd=0.6u ps=0.6u
m24 n12 n1 vss vss nch w=0.2u l=0.05u ad=0.02p as=0.02p pd=0.6u ps=0.6u
m25 n6 n3 n13 vdd pch w=0.3u l=0.05u ad=0.03p as=0.03p pd=0.8u ps=0.8u
m26 n13 n1 vdd vdd pch w=0.3u l=0.05u ad=0.03p as=0.03p pd=0.8u ps=0.8u
m27 Q n6 vss vss nch w=0.2u l=0.05u ad=0.02p as=0.02p pd=0.6u ps=0.6u
m28 vdd n6 Q vdd pch w=0.3u l=0.05u ad=0.03p as=0.03p pd=0.8u ps=0.8u
m29 QN n1 vss vss nch w=0.2u l=0.05u ad=0.02p as=0.02p pd=0.6u ps=0.6u
m30 vdd n1 QN vdd pch w=0.3u l=0.05u ad=0.03p as=0.03p pd=0.8u ps=0.8u
.ends

.subckt dffr_x2 d ck rn q qn vdd vss
m1 n2 CK vss vss nch w=0.2u l=0.05u ad=0.02p as=0.02p pd=0.6u ps=0.6u
m2 vdd CK n2 vdd pch w=0.3u l=0.05u ad=0.03p as=0.03p pd=0.8u ps=0.8u
m3 n3 n2 vss vss nch w=0.2u l=0.05u ad=0.02p as=0.02p pd=0.6u ps=0.6u
m4 vdd n2 n3 vdd pch w=0.3u l=0.05u ad=0.03p as=0.03p pd=0.8u ps=0.8u
m5 n7 RN vss vss nch w=0.2u l=0.05u ad=0.02p as=0.02p pd=0.6u ps=0.6u
m6 vdd RN n7 vdd pch w=0.3u l=0.05u ad=0.03p as=0.03p pd=0.8u ps=0.8u
m7 D n2 n4 vss nch w=0.2u l=0.05u ad=0.02p as=0.02p pd=0.6u ps=0.6u
m8 D n3 n4 vdd pch w=0.3u l=0.05u ad=0.03p as=0.03p pd=0.8u ps=0.8u
m9 n5 n4 n8 vss nch w=0.4u l=0.05u ad=0.04p as=0.04p pd=1u ps=1u
m10 n8 RN vss vss nch w=0.4u l=0.05u ad=0.04p as=0.04p pd=1u ps=1u
m11 vdd n4 n5 vdd pch w=0.3u l=0.05u ad=0.03p as=0.03p pd=0.8u ps=0.8u
m12 vdd RN n5 vdd pch w=0.3u l=0.05u ad=0.03p as=0.03p pd=0.8u ps=0.8u
m13 n4 n3 n9 vss nch w=0.2u l=0.05u ad=0.02p as=0.02p pd=0.6u ps=0.6u
m14 n9 n5 vss vss nch w=0.2u l=0.05u ad=0.02p as=0.02p pd=0.6u ps=0.6u
m15 n4 n2 n10 vdd pch w=0.3u l=0.05u ad=0.03p as=0.03p pd=0.8u ps=0.8u
m16 n10 n5 vdd vdd pch w=0.3u l=0.05u ad=0.03p as=0.03p pd=0.8u ps=0.8u
m17 n5 n3 n6 vss nch w=0.2u l=0.05u ad=0.02p as=0.02p pd=0.6u ps=0.6u
m18 n5 n2 n6 vdd pch w=0.3u l=0.05u ad=0.03p as=0.03p pd=0.8u ps=0.8u
m19 n1 n6 vss vss nch w=0.2u l=0.05u ad=0.02p as=0.02p pd=0.6u ps=0.6u
m20 n1 n7 vss vss nch w=0.2u l=0.05u ad=0.02p as=0.02p pd=0.6u ps=0.6u
m21 vdd n6 n11 vdd pch w=0.6u l=0.05u ad=0.06p as=0.06p pd=1.4u ps=1.4u
m22 n11 n7 n1 vdd pch w=0.6u l=0.05u ad=0.06p as=0.06p pd=1.4u ps=1.4u
m23 n6 n2 n12 vss nch w=0.2u l=0.05u ad=0.02p as=0.02p pd=0.6u ps=0.6u
m24 n12 n1 vss vss nch w=0.2u l=0.05u ad=0.02p as=0.02p pd=0.6u ps=0.6u
m25 n6 n3 n13 vdd pch w=0.3u l=0.05u ad=0.03p as=0.03p pd=0.8u ps=0.8u
m26 n13 n1 vdd vdd pch w=0.3u l=0.05u ad=0.03p as=0.03p pd=0.8u ps=0.8u
m27 Q n6 vss vss nch w=0.4u l=0.05u ad=0.04p as=0.04p pd=1u ps=1u
m28 vdd n6 Q vdd pch w=0.6u l=0.05u ad=0.06p as=0.06p pd=1.4u ps=1.4u
m29 QN n1 vss vss nch w=0.4u l=0.05u ad=0.04p as=0.04p pd=1u ps=1u
m30 vdd n1 QN vdd pch w=0.6u l=0.05u ad=0.06p as=0.06p pd=1.4u ps=1.4u
.ends

.subckt dffs_x1 d ck sn q qn vdd vss
m1 n2 CK vss vss nch w=0.2u l=0.05u ad=0.02p as=0.02p pd=0.6u ps=0.6u
m2 vdd CK n2 vdd pch w=0.3u l=0.05u ad=0.03p as=0.03p pd=0.8u ps=0.8u
m3 n3 n2 vss vss nch w=0.2u l=0.05u ad=0.02p as=0.02p pd=0.6u ps=0.6u
m4 vdd n2 n3 vdd pch w=0.3u l=0.05u ad=0.03p as=0.03p pd=0.8u ps=0.8u
m5 n7 SN vss vss nch w=0.2u l=0.05u ad=0.02p as=0.02p pd=0.6u ps=0.6u
m6 vdd SN n7 vdd pch w=0.3u l=0.05u ad=0.03p as=0.03p pd=0.8u ps=0.8u
m7 D n2 n4 vss nch w=0.2u l=0.05u ad=0.02p as=0.02p pd=0.6u ps=0.6u
m8 D n3 n4 vdd pch w=0.3u l=0.05u ad=0.03p as=0.03p pd=0.8u ps=0.8u
m9 n5 n4 vss vss nch w=0.2u l=0.05u ad=0.02p as=0.02p pd=0.6u ps=0.6u
m10 n5 n7 vss vss nch w=0.2u l=0.05u ad=0.02p as=0.02p pd=0.6u ps=0.6u
m11 vdd n4 n8 vdd pch w=0.6u l=0.05u ad=0.06p as=0.06p pd=1.4u ps=1.4u
m12 n8 n7 n5 vdd pch w=0.6u l=0.05u ad=0.06p as=0.06p pd=1.4u ps=1.4u
m13 n4 n3 n9 vss nch w=0.2u l=0.05u ad=0.02p as=0.02p pd=0.6u ps=0.6u
m14 n9 n5 vss vss nch w=0.2u l=0.05u ad=0.02p as=0.02p pd=0.6u ps=0.6u
m15 n4 n2 n10 vdd pch w=0.3u l=0.05u ad=0.03p as=0.03p pd=0.8u ps=0.8u
m16 n10 n5 vdd vdd pch w=0.3u l=0.05u ad=0.03p as=0.03p pd=0.8u ps=0.8u
m17 n5 n3 n6 vss nch w=0.2u l=0.05u ad=0.02p as=0.02p pd=0.6u ps=0.6u
m18 n5 n2 n6 vdd pch w=0.3u l=0.05u ad=0.03p as=0.03p pd=0.8u ps=0.8u
m19 n1 n6 n11 vss nch w=0.4u l=0.05u ad=0.04p as=0.04p pd=1u ps=1u
m20 n11 SN vss vss nch w=0.4u l=0.05u ad=0.04p as=0.04p pd=1u ps=1u
m21 vdd n6 n1 vdd pch w=0.3u l=0.05u ad=0.03p as=0.03p pd=0.8u ps=0.8u
m22 vdd SN n1 vdd pch w=0.3u l=0.05u ad=0.03p as=0.03p pd=0.8u ps=0.8u
m23 n6 n2 n12 vss nch w=0.2u l=0.05u ad=0.02p as=0.02p pd=0.6u ps=0.6u
m24 n12 n1 vss vss nch w=0.2u l=0.05u ad=0.02p as=0.02p pd=0.6u ps=0.6u
m25 n6 n3 n13 vdd pch w=0.3u l=0.05u ad=0.03p as=0.03p pd=0.8u ps=0.8u
m26 n13 n1 vdd vdd pch w=0.3u l=0.05u ad=0.03p as=0.03p pd=0.8u ps=0.8u
m27 Q n6 vss vss nch w=0.2u l=0.05u ad=0.02p as=0.02p pd=0.6u ps=0.6u
m28 vdd n6 Q vdd pch w=0.3u l=0.05u ad=0.03p as=0.03p pd=0.8u ps=0.8u
m29 QN n1 vss vss nch w=0.2u l=0.05u ad=0.02p as=0.02p pd=0.6u ps=0.6u
m30 vdd n1 QN vdd pch w=0.3u l=0.05u ad=0.03p as=0.03p pd=0.8u ps=0.8u
.ends

.subckt dffs_x2 d ck sn q qn vdd vss
m1 n2 CK vss vss nch w=0.2u l=0.05u ad=0.02p as=0.02p pd=0.6u ps=0.6u
m2 vdd CK n2 vdd pch w=0.3u l=0.05u ad=0.03p as=0.03p pd=0.8u ps=0.8u
m3 n3 n2 vss vss nch w=0.2u l=0.05u ad=0.02p as=0.02p pd=0.6u ps=0.6u
m4 vdd n2 n3 vdd pch w=0.3u l=0.05u ad=0.03p as=0.03p pd=0.8u ps=0.8u
m5 n7 SN vss vss nch w=0.2u l=0.05u ad=0.02p as=0.02p pd=0.6u ps=0.6u
m6 vdd SN n7 vdd pch w=0.3u l=0.05u ad=0.03p as=0.03p pd=0.8u ps=0.8u
m7 D n2 n4 vss nch w=0.2u l=0.05u ad=0.02p as=0.02p pd=0.6u ps=0.6u
m8 D n3 n4 vdd pch w=0.3u l=0.05u ad=0.03p as=0.03p pd=0.8u ps=0.8u
m9 n5 n4 vss vss nch w=0.2u l=0.05u ad=0.02p as=0.02p pd=0.6u ps=0.6u
m10 n5 n7 vss vss nch w=0.2u l=0.05u ad=0.02p as=0.02p pd=0.6u ps=0.6u
m11 vdd n4 n8 vdd pch w=0.6u l=0.05u ad=0.06p as=0.06p pd=1.4u ps=1.4u
m12 n8 n7 n5 vdd pch w=0.6u l=0.05u ad=0.06p as=0.06p pd=1.4u ps=1.4u
m13 n4 n3 n9 vss nch w=0.2u l=0.05u ad=0.02p as=0.02p pd=0.6u ps=0.6u
m14 n9 n5 vss vss nch w=0.2u l=0.05u ad=0.02p as=0.02p pd=0.6u ps=0.6u
m15 n4 n2 n10 vdd pch w=0.3u l=0.05u ad=0.03p as=0.03p pd=0.8u ps=0.8u
m16 n10 n5 vdd vdd pch w=0.3u l=0.05u ad=0.03p as=0.03p pd=0.8u ps=0.8u
m17 n5 n3 n6 vss nch w=0.2u l=0.05u ad=0.02p as=0.02p pd=0.6u ps=0.6u
m18 n5 n2 n6 vdd pch w=0.3u l=0.05u ad=0.03p as=0.03p pd=0.8u ps=0.8u
m19 n1 n6 n11 vss nch w=0.4u l=0.05u ad=0.04p as=0.04p pd=1u ps=1u
m20 n11 SN vss vss nch w=0.4u l=0.05u ad=0.04p as=0.04p pd=1u ps=1u
m21 vdd n6 n1 vdd pch w=0.3u l=0.05u ad=0.03p as=0.03p pd=0.8u ps=0.8u
m22 vdd SN n1 vdd pch w=0.3u l=0.05u ad=0.03p as=0.03p pd=0.8u ps=0.8u
m23 n6 n2 n12 vss nch w=0.2u l=0.05u ad=0.02p as=0.02p pd=0.6u ps=0.6u
m24 n12 n1 vss vss nch w=0.2u l=0.05u ad=0.02p as=0.02p pd=0.6u ps=0.6u
m25 n6 n3 n13 vdd pch w=0.3u l=0.05u ad=0.03p as=0.03p pd=0.8u ps=0.8u
m26 n13 n1 vdd vdd pch w=0.3u l=0.05u ad=0.03p as=0.03p pd=0.8u ps=0.8u
m27 Q n6 vss vss nch w=0.4u l=0.05u ad=0.04p as=0.04p pd=1u ps=1u
m28 vdd n6 Q vdd pch w=0.6u l=0.05u ad=0.06p as=0.06p pd=1.4u ps=1.4u
m29 QN n1 vss vss nch w=0.4u l=0.05u ad=0.04p as=0.04p pd=1u ps=1u
m30 vdd n1 QN vdd pch w=0.6u l=0.05u ad=0.06p as=0.06p pd=1.4u ps=1.4u
.ends

.subckt dffrs_x1 d ck rn sn q qn vdd vss
m1 n2 CK vss vss nch w=0.2u l=0.05u ad=0.02p as=0.02p pd=0.6u ps=0.6u
m2 vdd CK n2 vdd pch w=0.3u l=0.05u ad=0.03p as=0.03p pd=0.8u ps=0.8u
m3 n3 n2 vss vss nch w=0.2u l=0.05u ad=0.02p as=0.02p pd=0.6u ps=0.6u
m4 vdd n2 n3 vdd pch w=0.3u l=0.05u ad=0.03p as=0.03p pd=0.8u ps=0.8u
m5 n7 RN vss vss nch w=0.2u l=0.05u ad=0.02p as=0.02p pd=0.6u ps=0.6u
m6 vdd RN n7 vdd pch w=0.3u l=0.05u ad=0.03p as=0.03p pd=0.8u ps=0.8u
m7 n8 SN vss vss nch w=0.2u l=0.05u ad=0.02p as=0.02p pd=0.6u ps=0.6u
m8 vdd SN n8 vdd pch w=0.3u l=0.05u ad=0.03p as=0.03p pd=0.8u ps=0.8u
m9 D n2 n4 vss nch w=0.2u l=0.05u ad=0.02p as=0.02p pd=0.6u ps=0.6u
m10 D n3 n4 vdd pch w=0.3u l=0.05u ad=0.03p as=0.03p pd=0.8u ps=0.8u
m11 n5 n4 n9 vss nch w=0.4u l=0.05u ad=0.04p as=0.04p pd=1u ps=1u
m12 n5 n8 n9 vss nch w=0.4u l=0.05u ad=0.04p as=0.04p pd=1u ps=1u
m13 n9 RN vss vss nch w=0.4u l=0.05u ad=0.04p as=0.04p pd=1u ps=1u
m14 vdd n4 n10 vdd pch w=0.6u l=0.05u ad=0.06p as=0.06p pd=1.4u ps=1.4u
m15 n10 n8 n5 vdd pch w=0.6u l=0.05u ad=0.06p as=0.06p pd=1.4u ps=1.4u
m16 vdd RN n5 vdd pch w=0.3u l=0.05u ad=0.03p as=0.03p pd=0.8u ps=0.8u
m17 n4 n3 n11 vss nch w=0.2u l=0.05u ad=0.02p as=0.02p pd=0.6u ps=0.6u
m18 n11 n5 vss vss nch w=0.2u l=0.05u ad=0.02p as=0.02p pd=0.6u ps=0.6u
m19 n4 n2 n12 vdd pch w=0.3u l=0.05u ad=0.03p as=0.03p pd=0.8u ps=0.8u
m20 n12 n5 vdd vdd pch w=0.3u l=0.05u ad=0.03p as=0.03p pd=0.8u ps=0.8u
m21 n5 n3 n6 vss nch w=0.2u l=0.05u ad=0.02p as=0.02p pd=0.6u ps=0.6u
m22 n5 n2 n6 vdd pch w=0.3u l=0.05u ad=0.03p as=0.03p pd=0.8u ps=0.8u
m23 n1 n6 n13 vss nch w=0.4u l=0.05u ad=0.04p as=0.04p pd=1u ps=1u
m24 n13 SN vss vss nch w=0.4u l=0.05u ad=0.04p as=0.04p pd=1u ps=1u
m25 n1 n7 vss vss nch w=0.2u l=0.05u ad=0.02p as=0.02p pd=0.6u ps=0.6u
m26 vdd n6 n14 vdd pch w=0.6u l=0.05u ad=0.06p as=0.06p pd=1.4u ps=1.4u
m27 vdd SN n14 vdd pch w=0.6u l=0.05u ad=0.06p as=0.06p pd=1.4u ps=1.4u
m28 n14 n7 n1 vdd pch w=0.6u l=0.05u ad=0.06p as=0.06p pd=1.4u ps=1.4u
m29 n6 n2 n15 vss nch w=0.2u l=0.05u ad=0.02p as=0.02p pd=0.6u ps=0.6u
m30 n15 n1 vss vss nch w=0.2u l=0.05u ad=0.02p as=0.02p pd=0.6u ps=0.6u
m31 n6 n3 n16 vdd pch w=0.3u l=0.05u ad=0.03p as=0.03p pd=0.8u ps=0.8u
m32 n16 n1 vdd vdd pch w=0.3u l=0.05u ad=0.03p as=0.03p pd=0.8u ps=0.8u
m33 Q n6 vss vss nch w=0.2u l=0.05u ad=0.02p as=0.02p pd=0.6u ps=0.6u
m34 vdd n6 Q vdd pch w=0.3u l=0.05u ad=0.03p as=0.03p pd=0.8u ps=0.8u
m35 QN n1 vss vss nch w=0.2u l=0.05u ad=0.02p as=0.02p pd=0.6u ps=0.6u
m36 vdd n1 QN vdd pch w=0.3u l=0.05u ad=0.03p as=0.03p pd=0.8u ps=0.8u
.ends

.subckt dffe_x1 d e ck q qn vdd vss
m1 n2 E vss vss nch w=0.2u l=0.05u ad=0.02p as=0.02p pd=0.6u ps=0.6u
m2 vdd E n2 vdd pch w=0.3u l=0.05u ad=0.03p as=0.03p pd=0.8u ps=0.8u
m3 n4 D n5 vss nch w=0.4u l=0.05u ad=0.04p as=0.04p pd=1u ps=1u
m4 n5 E vss vss nch w=0.4u l=0.05u ad=0.04p as=0.04p pd=1u ps=1u
m5 n4 n1 n6 vss nch w=0.4u l=0.05u ad=0.04p as=0.04p pd=1u ps=1u
m6 n6 n2 vss vss nch w=0.4u l=0.05u ad=0.04p as=0.04p pd=1u ps=1u
m7 vdd D n7 vdd pch w=0.6u l=0.05u ad=0.06p as=0.06p pd=1.4u ps=1.4u
m8 vdd E n7 vdd pch w=0.6u l=0.05u ad=0.06p as=0.06p pd=1.4u ps=1.4u
m9 n7 n1 n4 vdd pch w=0.6u l=0.05u ad=0.06p as=0.06p pd=1.4u ps=1.4u
m10 n7 n2 n4 vdd pch w=0.6u l=0.05u ad=0.06p as=0.06p pd=1.4u ps=1.4u
m11 n3 n4 vss vss nch w=0.2u l=0.05u ad=0.02p as=0.02p pd=0.6u ps=0.6u
m12 vdd n4 n3 vdd pch w=0.3u l=0.05u ad=0.03p as=0.03p pd=0.8u ps=0.8u
m13 n8 CK vss vss nch w=0.2u l=0.05u ad=0.02p as=0.02p pd=0.6u ps=0.6u
m14 vdd CK n8 vdd pch w=0.3u l=0.05u ad=0.03p as=0.03p pd=0.8u ps=0.8u
m15 n9 n8 vss vss nch w=0.2u l=0.05u ad=0.02p as=0.02p pd=0.6u ps=0.6u
m16 vdd n8 n9 vdd pch w=0.3u l=0.05u ad=0.03p as=0.03p pd=0.8u ps=0.8u
m17 n3 n8 n10 vss nch w=0.2u l=0.05u ad=0.02p as=0.02p pd=0.6u ps=0.6u
m18 n3 n9 n10 vdd pch w=0.3u l=0.05u ad=0.03p as=0.03p pd=0.8u ps=0.8u
m19 n11 n10 vss vss nch w=0.2u l=0.05u ad=0.02p as=0.02p pd=0.6u ps=0.6u
m20 vdd n10 n11 vdd pch w=0.3u l=0.05u ad=0.03p as=0.03p pd=0.8u ps=0.8u
m21 n10 n9 n13 vss nch w=0.2u l=0.05u ad=0.02p as=0.02p pd=0.6u ps=0.6u
m22 n13 n11 vss vss nch w=0.2u l=0.05u ad=0.02p as=0.02p pd=0.6u ps=0.6u
m23 n10 n8 n14 vdd pch w=0.3u l=0.05u ad=0.03p as=0.03p pd=0.8u ps=0.8u
m24 n14 n11 vdd vdd pch w=0.3u l=0.05u ad=0.03p as=0.03p pd=0.8u ps=0.8u
m25 n11 n9 n12 vss nch w=0.2u l=0.05u ad=0.02p as=0.02p pd=0.6u ps=0.6u
m26 n11 n8 n12 vdd pch w=0.3u l=0.05u ad=0.03p as=0.03p pd=0.8u ps=0.8u
m27 n1 n12 vss vss nch w=0.2u l=0.05u ad=0.02p as=0.02p pd=0.6u ps=0.6u
m28 vdd n12 n1 vdd pch w=0.3u l=0.05u ad=0.03p as=0.03p pd=0.8u ps=0.8u
m29 n12 n8 n15 vss nch w=0.2u l=0.05u ad=0.02p as=0.02p pd=0.6u ps=0.6u
m30 n15 n1 vss vss nch w=0.2u l=0.05u ad=0.02p as=0.02p pd=0.6u ps=0.6u
m31 n12 n9 n16 vdd pch w=0.3u l=0.05u ad=0.03p as=0.03p pd=0.8u ps=0.8u
m32 n16 n1 vdd vdd pch w=0.3u l=0.05u ad=0.03p as=0.03p pd=0.8u ps=0.8u
m33 Q n12 vss vss nch w=0.2u l=0.05u ad=0.02p as=0.02p pd=0.6u ps=0.6u
m34 vdd n12 Q vdd pch w=0.3u l=0.05u ad=0.03p as=0.03p pd=0.8u ps=0.8u
m35 QN n1 vss vss nch w=0.2u l=0.05u ad=0.02p as=0.02p pd=0.6u ps=0.6u
m36 vdd n1 QN vdd pch w=0.3u l=0.05u ad=0.03p as=0.03p pd=0.8u ps=0.8u
.ends

.subckt sdff_x1 d si se ck q qn vdd vss
m1 n1 SE vss vss nch w=0.2u l=0.05u ad=0.02p as=0.02p pd=0.6u ps=0.6u
m2 vdd SE n1 vdd pch w=0.3u l=0.05u ad=0.03p as=0.03p pd=0.8u ps=0.8u
m3 n3 SI n4 vss nch w=0.4u l=0.05u ad=0.04p as=0.04p pd=1u ps=1u
m4 n4 SE vss vss nch w=0.4u l=0.05u ad=0.04p as=0.04p pd=1u ps=1u
m5 n3 D n5 vss nch w=0.4u l=0.05u ad=0.04p as=0.04p pd=1u ps=1u
m6 n5 n1 vss vss nch w=0.4u l=0.05u ad=0.04p as=0.04p pd=1u ps=1u
m7 vdd SI n6 vdd pch w=0.6u l=0.05u ad=0.06p as=0.06p pd=1.4u ps=1.4u
m8 vdd SE n6 vdd pch w=0.6u l=0.05u ad=0.06p as=0.06p pd=1.4u ps=1.4u
m9 n6 D n3 vdd pch w=0.6u l=0.05u ad=0.06p as=0.06p pd=1.4u ps=1.4u
m10 n6 n1 n3 vdd pch w=0.6u l=0.05u ad=0.06p as=0.06p pd=1.4u ps=1.4u
m11 n2 n3 vss vss nch w=0.2u l=0.05u ad=0.02p as=0.02p pd=0.6u ps=0.6u
m12 vdd n3 n2 vdd pch w=0.3u l=0.05u ad=0.03p as=0.03p pd=0.8u ps=0.8u
m13 n8 CK vss vss nch w=0.2u l=0.05u ad=0.02p as=0.02p pd=0.6u ps=0.6u
m14 vdd CK n8 vdd pch w=0.3u l=0.05u ad=0.03p as=0.03p pd=0.8u ps=0.8u
m15 n9 n8 vss vss nch w=0.2u l=0.05u ad=0.02p as=0.02p pd=0.6u ps=0.6u
m16 vdd n8 n9 vdd pch w=0.3u l=0.05u ad=0.03p as=0.03p pd=0.8u ps=0.8u
m17 n2 n8 n10 vss nch w=0.2u l=0.05u ad=0.02p as=0.02p pd=0.6u ps=0.6u
m18 n2 n9 n10 vdd pch w=0.3u l=0.05u ad=0.03p as=0.03p pd=0.8u ps=0.8u
m19 n11 n10 vss vss nch w=0.2u l=0.05u ad=0.02p as=0.02p pd=0.6u ps=0.6u
m20 vdd n10 n11 vdd pch w=0.3u l=0.05u ad=0.03p as=0.03p pd=0.8u ps=0.8u
m21 n10 n9 n13 vss nch w=0.2u l=0.05u ad=0.02p as=0.02p pd=0.6u ps=0.6u
m22 n13 n11 vss vss nch w=0.2u l=0.05u ad=0.02p as=0.02p pd=0.6u ps=0.6u
m23 n10 n8 n14 vdd pch w=0.3u l=0.05u ad=0.03p as=0.03p pd=0.8u ps=0.8u
m24 n14 n11 vdd vdd pch w=0.3u l=0.05u ad=0.03p as=0.03p pd=0.8u ps=0.8u
m25 n11 n9 n12 vss nch w=0.2u l=0.05u ad=0.02p as=0.02p pd=0.6u ps=0.6u
m26 n11 n8 n12 vdd pch w=0.3u l=0.05u ad=0.03p as=0.03p pd=0.8u ps=0.8u
m27 n7 n12 vss vss nch w=0.2u l=0.05u ad=0.02p as=0.02p pd=0.6u ps=0.6u
m28 vdd n12 n7 vdd pch w=0.3u l=0.05u ad=0.03p as=0.03p pd=0.8u ps=0.8u
m29 n12 n8 n15 vss nch w=0.2u l=0.05u ad=0.02p as=0.02p pd=0.6u ps=0.6u
m30 n15 n7 vss vss nch w=0.2u l=0.05u ad=0.02p as=0.02p pd=0.6u ps=0.6u
m31 n12 n9 n16 vdd pch w=0.3u l=0.05u ad=0.03p as=0.03p pd=0.8u ps=0.8u
m32 n16 n7 vdd vdd pch w=0.3u l=0.05u ad=0.03p as=0.03p pd=0.8u ps=0.8u
m33 Q n12 vss vss nch w=0.2u l=0.05u ad=0.02p as=0.02p pd=0.6u ps=0.6u
m34 vdd n12 Q vdd pch w=0.3u l=0.05u ad=0.03p as=0.03p pd=0.8u ps=0.8u
m35 QN n7 vss vss nch w=0.2u l=0.05u ad=0.02p as=0.02p pd=0.6u ps=0.6u
m36 vdd n7 QN vdd pch w=0.3u l=0.05u ad=0.03p as=0.03p pd=0.8u ps=0.8u
.ends

.subckt sdff_x2 d si se ck q qn vdd vss
m1 n1 SE vss vss nch w=0.2u l=0.05u ad=0.02p as=0.02p pd=0.6u ps=0.6u
m2 vdd SE n1 vdd pch w=0.3u l=0.05u ad=0.03p as=0.03p pd=0.8u ps=0.8u
m3 n3 SI n4 vss nch w=0.4u l=0.05u ad=0.04p as=0.04p pd=1u ps=1u
m4 n4 SE vss vss nch w=0.4u l=0.05u ad=0.04p as=0.04p pd=1u ps=1u
m5 n3 D n5 vss nch w=0.4u l=0.05u ad=0.04p as=0.04p pd=1u ps=1u
m6 n5 n1 vss vss nch w=0.4u l=0.05u ad=0.04p as=0.04p pd=1u ps=1u
m7 vdd SI n6 vdd pch w=0.6u l=0.05u ad=0.06p as=0.06p pd=1.4u ps=1.4u
m8 vdd SE n6 vdd pch w=0.6u l=0.05u ad=0.06p as=0.06p pd=1.4u ps=1.4u
m9 n6 D n3 vdd pch w=0.6u l=0.05u ad=0.06p as=0.06p pd=1.4u ps=1.4u
m10 n6 n1 n3 vdd pch w=0.6u l=0.05u ad=0.06p as=0.06p pd=1.4u ps=1.4u
m11 n2 n3 vss vss nch w=0.2u l=0.05u ad=0.02p as=0.02p pd=0.6u ps=0.6u
m12 vdd n3 n2 vdd pch w=0.3u l=0.05u ad=0.03p as=0.03p pd=0.8u ps=0.8u
m13 n8 CK vss vss nch w=0.2u l=0.05u ad=0.02p as=0.02p pd=0.6u ps=0.6u
m14 vdd CK n8 vdd pch w=0.3u l=0.05u ad=0.03p as=0.03p pd=0.8u ps=0.8u
m15 n9 n8 vss vss nch w=0.2u l=0.05u ad=0.02p as=0.02p pd=0.6u ps=0.6u
m16 vdd n8 n9 vdd pch w=0.3u l=0.05u ad=0.03p as=0.03p pd=0.8u ps=0.8u
m17 n2 n8 n10 vss nch w=0.2u l=0.05u ad=0.02p as=0.02p pd=0.6u ps=0.6u
m18 n2 n9 n10 vdd pch w=0.3u l=0.05u ad=0.03p as=0.03p pd=0.8u ps=0.8u
m19 n11 n10 vss vss nch w=0.2u l=0.05u ad=0.02p as=0.02p pd=0.6u ps=0.6u
m20 vdd n10 n11 vdd pch w=0.3u l=0.05u ad=0.03p as=0.03p pd=0.8u ps=0.8u
m21 n10 n9 n13 vss nch w=0.2u l=0.05u ad=0.02p as=0.02p pd=0.6u ps=0.6u
m22 n13 n11 vss vss nch w=0.2u l=0.05u ad=0.02p as=0.02p pd=0.6u ps=0.6u
m23 n10 n8 n14 vdd pch w=0.3u l=0.05u ad=0.03p as=0.03p pd=0.8u ps=0.8u
m24 n14 n11 vdd vdd pch w=0.3u l=0.05u ad=0.03p as=0.03p pd=0.8u ps=0.8u
m25 n11 n9 n12 vss nch w=0.2u l=0.05u ad=0.02p as=0.02p pd=0.6u ps=0.6u
m26 n11 n8 n12 vdd pch w=0.3u l=0.05u ad=0.03p as=0.03p pd=0.8u ps=0.8u
m27 n7 n12 vss vss nch w=0.2u l=0.05u ad=0.02p as=0.02p pd=0.6u ps=0.6u
m28 vdd n12 n7 vdd pch w=0.3u l=0.05u ad=0.03p as=0.03p pd=0.8u ps=0.8u
m29 n12 n8 n15 vss nch w=0.2u l=0.05u ad=0.02p as=0.02p pd=0.6u ps=0.6u
m30 n15 n7 vss vss nch w=0.2u l=0.05u ad=0.02p as=0.02p pd=0.6u ps=0.6u
m31 n12 n9 n16 vdd pch w=0.3u l=0.05u ad=0.03p as=0.03p pd=0.8u ps=0.8u
m32 n16 n7 vdd vdd pch w=0.3u l=0.05u ad=0.03p as=0.03p pd=0.8u ps=0.8u
m33 Q n12 vss vss nch w=0.4u l=0.05u ad=0.04p as=0.04p pd=1u ps=1u
m34 vdd n12 Q vdd pch w=0.6u l=0.05u ad=0.06p as=0.06p pd=1.4u ps=1.4u
m35 QN n7 vss vss nch w=0.4u l=0.05u ad=0.04p as=0.04p pd=1u ps=1u
m36 vdd n7 QN vdd pch w=0.6u l=0.05u ad=0.06p as=0.06p pd=1.4u ps=1.4u
.ends

.subckt sdffr_x1 d si se ck rn q qn vdd vss
m1 n1 SE vss vss nch w=0.2u l=0.05u ad=0.02p as=0.02p pd=0.6u ps=0.6u
m2 vdd SE n1 vdd pch w=0.3u l=0.05u ad=0.03p as=0.03p pd=0.8u ps=0.8u
m3 n3 SI n4 vss nch w=0.4u l=0.05u ad=0.04p as=0.04p pd=1u ps=1u
m4 n4 SE vss vss nch w=0.4u l=0.05u ad=0.04p as=0.04p pd=1u ps=1u
m5 n3 D n5 vss nch w=0.4u l=0.05u ad=0.04p as=0.04p pd=1u ps=1u
m6 n5 n1 vss vss nch w=0.4u l=0.05u ad=0.04p as=0.04p pd=1u ps=1u
m7 vdd SI n6 vdd pch w=0.6u l=0.05u ad=0.06p as=0.06p pd=1.4u ps=1.4u
m8 vdd SE n6 vdd pch w=0.6u l=0.05u ad=0.06p as=0.06p pd=1.4u ps=1.4u
m9 n6 D n3 vdd pch w=0.6u l=0.05u ad=0.06p as=0.06p pd=1.4u ps=1.4u
m10 n6 n1 n3 vdd pch w=0.6u l=0.05u ad=0.06p as=0.06p pd=1.4u ps=1.4u
m11 n2 n3 vss vss nch w=0.2u l=0.05u ad=0.02p as=0.02p pd=0.6u ps=0.6u
m12 vdd n3 n2 vdd pch w=0.3u l=0.05u ad=0.03p as=0.03p pd=0.8u ps=0.8u
m13 n8 CK vss vss nch w=0.2u l=0.05u ad=0.02p as=0.02p pd=0.6u ps=0.6u
m14 vdd CK n8 vdd pch w=0.3u l=0.05u ad=0.03p as=0.03p pd=0.8u ps=0.8u
m15 n9 n8 vss vss nch w=0.2u l=0.05u ad=0.02p as=0.02p pd=0.6u ps=0.6u
m16 vdd n8 n9 vdd pch w=0.3u l=0.05u ad=0.03p as=0.03p pd=0.8u ps=0.8u
m17 n13 RN vss vss nch w=0.2u l=0.05u ad=0.02p as=0.02p pd=0.6u ps=0.6u
m18 vdd RN n13 vdd pch w=0.3u l=0.05u ad=0.03p as=0.03p pd=0.8u ps=0.8u
m19 n2 n8 n10 vss nch w=0.2u l=0.05u ad=0.02p as=0.02p pd=0.6u ps=0.6u
m20 n2 n9 n10 vdd pch w=0.3u l=0.05u ad=0.03p as=0.03p pd=0.8u ps=0.8u
m21 n11 n10 n14 vss nch w=0.4u l=0.05u ad=0.04p as=0.04p pd=1u ps=1u
m22 n14 RN vss vss nch w=0.4u l=0.05u ad=0.04p as=0.04p pd=1u ps=1u
m23 vdd n10 n11 vdd pch w=0.3u l=0.05u ad=0.03p as=0.03p pd=0.8u ps=0.8u
m24 vdd RN n11 vdd pch w=0.3u l=0.05u ad=0.03p as=0.03p pd=0.8u ps=0.8u
m25 n10 n9 n15 vss nch w=0.2u l=0.05u ad=0.02p as=0.02p pd=0.6u ps=0.6u
m26 n15 n11 vss vss nch w=0.2u l=0.05u ad=0.02p as=0.02p pd=0.6u ps=0.6u
m27 n10 n8 n16 vdd pch w=0.3u l=0.05u ad=0.03p as=0.03p pd=0.8u ps=0.8u
m28 n16 n11 vdd vdd pch w=0.3u l=0.05u ad=0.03p as=0.03p pd=0.8u ps=0.8u
m29 n11 n9 n12 vss nch w=0.2u l=0.05u ad=0.02p as=0.02p pd=0.6u ps=0.6u
m30 n11 n8 n12 vdd pch w=0.3u l=0.05u ad=0.03p as=0.03p pd=0.8u ps=0.8u
m31 n7 n12 vss vss nch w=0.2u l=0.05u ad=0.02p as=0.02p pd=0.6u ps=0.6u
m32 n7 n13 vss vss nch w=0.2u l=0.05u ad=0.02p as=0.02p pd=0.6u ps=0.6u
m33 vdd n12 n17 vdd pch w=0.6u l=0.05u ad=0.06p as=0.06p pd=1.4u ps=1.4u
m34 n17 n13 n7 vdd pch w=0.6u l=0.05u ad=0.06p as=0.06p pd=1.4u ps=1.4u
m35 n12 n8 n18 vss nch w=0.2u l=0.05u ad=0.02p as=0.02p pd=0.6u ps=0.6u
m36 n18 n7 vss vss nch w=0.2u l=0.05u ad=0.02p as=0.02p pd=0.6u ps=0.6u
m37 n12 n9 n19 vdd pch w=0.3u l=0.05u ad=0.03p as=0.03p pd=0.8u ps=0.8u
m38 n19 n7 vdd vdd pch w=0.3u l=0.05u ad=0.03p as=0.03p pd=0.8u ps=0.8u
m39 Q n12 vss vss nch w=0.2u l=0.05u ad=0.02p as=0.02p pd=0.6u ps=0.6u
m40 vdd n12 Q vdd pch w=0.3u l=0.05u ad=0.03p as=0.03p pd=0.8u ps=0.8u
m41 QN n7 vss vss nch w=0.2u l=0.05u ad=0.02p as=0.02p pd=0.6u ps=0.6u
m42 vdd n7 QN vdd pch w=0.3u l=0.05u ad=0.03p as=0.03p pd=0.8u ps=0.8u
.ends

.subckt sdffr_x2 d si se ck rn q qn vdd vss
m1 n1 SE vss vss nch w=0.2u l=0.05u ad=0.02p as=0.02p pd=0.6u ps=0.6u
m2 vdd SE n1 vdd pch w=0.3u l=0.05u ad=0.03p as=0.03p pd=0.8u ps=0.8u
m3 n3 SI n4 vss nch w=0.4u l=0.05u ad=0.04p as=0.04p pd=1u ps=1u
m4 n4 SE vss vss nch w=0.4u l=0.05u ad=0.04p as=0.04p pd=1u ps=1u
m5 n3 D n5 vss nch w=0.4u l=0.05u ad=0.04p as=0.04p pd=1u ps=1u
m6 n5 n1 vss vss nch w=0.4u l=0.05u ad=0.04p as=0.04p pd=1u ps=1u
m7 vdd SI n6 vdd pch w=0.6u l=0.05u ad=0.06p as=0.06p pd=1.4u ps=1.4u
m8 vdd SE n6 vdd pch w=0.6u l=0.05u ad=0.06p as=0.06p pd=1.4u ps=1.4u
m9 n6 D n3 vdd pch w=0.6u l=0.05u ad=0.06p as=0.06p pd=1.4u ps=1.4u
m10 n6 n1 n3 vdd pch w=0.6u l=0.05u ad=0.06p as=0.06p pd=1.4u ps=1.4u
m11 n2 n3 vss vss nch w=0.2u l=0.05u ad=0.02p as=0.02p pd=0.6u ps=0.6u
m12 vdd n3 n2 vdd pch w=0.3u l=0.05u ad=0.03p as=0.03p pd=0.8u ps=0.8u
m13 n8 CK vss vss nch w=0.2u l=0.05u ad=0.02p as=0.02p pd=0.6u ps=0.6u
m14 vdd CK n8 vdd pch w=0.3u l=0.05u ad=0.03p as=0.03p pd=0.8u ps=0.8u
m15 n9 n8 vss vss nch w=0.2u l=0.05u ad=0.02p as=0.02p pd=0.6u ps=0.6u
m16 vdd n8 n9 vdd pch w=0.3u l=0.05u ad=0.03p as=0.03p pd=0.8u ps=0.8u
m17 n13 RN vss vss nch w=0.2u l=0.05u ad=0.02p as=0.02p pd=0.6u ps=0.6u
m18 vdd RN n13 vdd pch w=0.3u l=0.05u ad=0.03p as=0.03p pd=0.8u ps=0.8u
m19 n2 n8 n10 vss nch w=0.2u l=0.05u ad=0.02p as=0.02p pd=0.6u ps=0.6u
m20 n2 n9 n10 vdd pch w=0.3u l=0.05u ad=0.03p as=0.03p pd=0.8u ps=0.8u
m21 n11 n10 n14 vss nch w=0.4u l=0.05u ad=0.04p as=0.04p pd=1u ps=1u
m22 n14 RN vss vss nch w=0.4u l=0.05u ad=0.04p as=0.04p pd=1u ps=1u
m23 vdd n10 n11 vdd pch w=0.3u l=0.05u ad=0.03p as=0.03p pd=0.8u ps=0.8u
m24 vdd RN n11 vdd pch w=0.3u l=0.05u ad=0.03p as=0.03p pd=0.8u ps=0.8u
m25 n10 n9 n15 vss nch w=0.2u l=0.05u ad=0.02p as=0.02p pd=0.6u ps=0.6u
m26 n15 n11 vss vss nch w=0.2u l=0.05u ad=0.02p as=0.02p pd=0.6u ps=0.6u
m27 n10 n8 n16 vdd pch w=0.3u l=0.05u ad=0.03p as=0.03p pd=0.8u ps=0.8u
m28 n16 n11 vdd vdd pch w=0.3u l=0.05u ad=0.03p as=0.03p pd=0.8u ps=0.8u
m29 n11 n9 n12 vss nch w=0.2u l=0.05u ad=0.02p as=0.02p pd=0.6u ps=0.6u
m30 n11 n8 n12 vdd pch w=0.3u l=0.05u ad=0.03p as=0.03p pd=0.8u ps=0.8u
m31 n7 n12 vss vss nch w=0.2u l=0.05u ad=0.02p as=0.02p pd=0.6u ps=0.6u
m32 n7 n13 vss vss nch w=0.2u l=0.05u ad=0.02p as=0.02p pd=0.6u ps=0.6u
m33 vdd n12 n17 vdd pch w=0.6u l=0.05u ad=0.06p as=0.06p pd=1.4u ps=1.4u
m34 n17 n13 n7 vdd pch w=0.6u l=0.05u ad=0.06p as=0.06p pd=1.4u ps=1.4u
m35 n12 n8 n18 vss nch w=0.2u l=0.05u ad=0.02p as=0.02p pd=0.6u ps=0.6u
m36 n18 n7 vss vss nch w=0.2u l=0.05u ad=0.02p as=0.02p pd=0.6u ps=0.6u
m37 n12 n9 n19 vdd pch w=0.3u l=0.05u ad=0.03p as=0.03p pd=0.8u ps=0.8u
m38 n19 n7 vdd vdd pch w=0.3u l=0.05u ad=0.03p as=0.03p pd=0.8u ps=0.8u
m39 Q n12 vss vss nch w=0.4u l=0.05u ad=0.04p as=0.04p pd=1u ps=1u
m40 vdd n12 Q vdd pch w=0.6u l=0.05u ad=0.06p as=0.06p pd=1.4u ps=1.4u
m41 QN n7 vss vss nch w=0.4u l=0.05u ad=0.04p as=0.04p pd=1u ps=1u
m42 vdd n7 QN vdd pch w=0.6u l=0.05u ad=0.06p as=0.06p pd=1.4u ps=1.4u
.ends

.subckt sdffs_x1 d si se ck sn q qn vdd vss
m1 n1 SE vss vss nch w=0.2u l=0.05u ad=0.02p as=0.02p pd=0.6u ps=0.6u
m2 vdd SE n1 vdd pch w=0.3u l=0.05u ad=0.03p as=0.03p pd=0.8u ps=0.8u
m3 n3 SI n4 vss nch w=0.4u l=0.05u ad=0.04p as=0.04p pd=1u ps=1u
m4 n4 SE vss vss nch w=0.4u l=0.05u ad=0.04p as=0.04p pd=1u ps=1u
m5 n3 D n5 vss nch w=0.4u l=0.05u ad=0.04p as=0.04p pd=1u ps=1u
m6 n5 n1 vss vss nch w=0.4u l=0.05u ad=0.04p as=0.04p pd=1u ps=1u
m7 vdd SI n6 vdd pch w=0.6u l=0.05u ad=0.06p as=0.06p pd=1.4u ps=1.4u
m8 vdd SE n6 vdd pch w=0.6u l=0.05u ad=0.06p as=0.06p pd=1.4u ps=1.4u
m9 n6 D n3 vdd pch w=0.6u l=0.05u ad=0.06p as=0.06p pd=1.4u ps=1.4u
m10 n6 n1 n3 vdd pch w=0.6u l=0.05u ad=0.06p as=0.06p pd=1.4u ps=1.4u
m11 n2 n3 vss vss nch w=0.2u l=0.05u ad=0.02p as=0.02p pd=0.6u ps=0.6u
m12 vdd n3 n2 vdd pch w=0.3u l=0.05u ad=0.03p as=0.03p pd=0.8u ps=0.8u
m13 n8 CK vss vss nch w=0.2u l=0.05u ad=0.02p as=0.02p pd=0.6u ps=0.6u
m14 vdd CK n8 vdd pch w=0.3u l=0.05u ad=0.03p as=0.03p pd=0.8u ps=0.8u
m15 n9 n8 vss vss nch w=0.2u l=0.05u ad=0.02p as=0.02p pd=0.6u ps=0.6u
m16 vdd n8 n9 vdd pch w=0.3u l=0.05u ad=0.03p as=0.03p pd=0.8u ps=0.8u
m17 n13 SN vss vss nch w=0.2u l=0.05u ad=0.02p as=0.02p pd=0.6u ps=0.6u
m18 vdd SN n13 vdd pch w=0.3u l=0.05u ad=0.03p as=0.03p pd=0.8u ps=0.8u
m19 n2 n8 n10 vss nch w=0.2u l=0.05u ad=0.02p as=0.02p pd=0.6u ps=0.6u
m20 n2 n9 n10 vdd pch w=0.3u l=0.05u ad=0.03p as=0.03p pd=0.8u ps=0.8u
m21 n11 n10 vss vss nch w=0.2u l=0.05u ad=0.02p as=0.02p pd=0.6u ps=0.6u
m22 n11 n13 vss vss nch w=0.2u l=0.05u ad=0.02p as=0.02p pd=0.6u ps=0.6u
m23 vdd n10 n14 vdd pch w=0.6u l=0.05u ad=0.06p as=0.06p pd=1.4u ps=1.4u
m24 n14 n13 n11 vdd pch w=0.6u l=0.05u ad=0.06p as=0.06p pd=1.4u ps=1.4u
m25 n10 n9 n15 vss nch w=0.2u l=0.05u ad=0.02p as=0.02p pd=0.6u ps=0.6u
m26 n15 n11 vss vss nch w=0.2u l=0.05u ad=0.02p as=0.02p pd=0.6u ps=0.6u
m27 n10 n8 n16 vdd pch w=0.3u l=0.05u ad=0.03p as=0.03p pd=0.8u ps=0.8u
m28 n16 n11 vdd vdd pch w=0.3u l=0.05u ad=0.03p as=0.03p pd=0.8u ps=0.8u
m29 n11 n9 n12 vss nch w=0.2u l=0.05u ad=0.02p as=0.02p pd=0.6u ps=0.6u
m30 n11 n8 n12 vdd pch w=0.3u l=0.05u ad=0.03p as=0.03p pd=0.8u ps=0.8u
m31 n7 n12 n17 vss nch w=0.4u l=0.05u ad=0.04p as=0.04p pd=1u ps=1u
m32 n17 SN vss vss nch w=0.4u l=0.05u ad=0.04p as=0.04p pd=1u ps=1u
m33 vdd n12 n7 vdd pch w=0.3u l=0.05u ad=0.03p as=0.03p pd=0.8u ps=0.8u
m34 vdd SN n7 vdd pch w=0.3u l=0.05u ad=0.03p as=0.03p pd=0.8u ps=0.8u
m35 n12 n8 n18 vss nch w=0.2u l=0.05u ad=0.02p as=0.02p pd=0.6u ps=0.6u
m36 n18 n7 vss vss nch w=0.2u l=0.05u ad=0.02p as=0.02p pd=0.6u ps=0.6u
m37 n12 n9 n19 vdd pch w=0.3u l=0.05u ad=0.03p as=0.03p pd=0.8u ps=0.8u
m38 n19 n7 vdd vdd pch w=0.3u l=0.05u ad=0.03p as=0.03p pd=0.8u ps=0.8u
m39 Q n12 vss vss nch w=0.2u l=0.05u ad=0.02p as=0.02p pd=0.6u ps=0.6u
m40 vdd n12 Q vdd pch w=0.3u l=0.05u ad=0.03p as=0.03p pd=0.8u ps=0.8u
m41 QN n7 vss vss nch w=0.2u l=0.05u ad=0.02p as=0.02p pd=0.6u ps=0.6u
m42 vdd n7 QN vdd pch w=0.3u l=0.05u ad=0.03p as=0.03p pd=0.8u ps=0.8u
.ends

.subckt dlh_x1 d e q vdd vss
m1 n1 E vss vss nch w=0.2u l=0.05u ad=0.02p as=0.02p pd=0.6u ps=0.6u
m2 vdd E n1 vdd pch w=0.3u l=0.05u ad=0.03p as=0.03p pd=0.8u ps=0.8u
m3 n2 n1 vss vss nch w=0.2u l=0.05u ad=0.02p as=0.02p pd=0.6u ps=0.6u
m4 vdd n1 n2 vdd pch w=0.3u l=0.05u ad=0.03p as=0.03p pd=0.8u ps=0.8u
m5 D n2 n3 vss nch w=0.2u l=0.05u ad=0.02p as=0.02p pd=0.6u ps=0.6u
m6 D n1 n3 vdd pch w=0.3u l=0.05u ad=0.03p as=0.03p pd=0.8u ps=0.8u
m7 n4 n3 vss vss nch w=0.2u l=0.05u ad=0.02p as=0.02p pd=0.6u ps=0.6u
m8 vdd n3 n4 vdd pch w=0.3u l=0.05u ad=0.03p as=0.03p pd=0.8u ps=0.8u
m9 n3 n1 n5 vss nch w=0.2u l=0.05u ad=0.02p as=0.02p pd=0.6u ps=0.6u
m10 n5 n4 vss vss nch w=0.2u l=0.05u ad=0.02p as=0.02p pd=0.6u ps=0.6u
m11 n3 n2 n6 vdd pch w=0.3u l=0.05u ad=0.03p as=0.03p pd=0.8u ps=0.8u
m12 n6 n4 vdd vdd pch w=0.3u l=0.05u ad=0.03p as=0.03p pd=0.8u ps=0.8u
m13 Q n4 vss vss nch w=0.2u l=0.05u ad=0.02p as=0.02p pd=0.6u ps=0.6u
m14 vdd n4 Q vdd pch w=0.3u l=0.05u ad=0.03p as=0.03p pd=0.8u ps=0.8u
.ends

.subckt dlh_x2 d e q vdd vss
m1 n1 E vss vss nch w=0.2u l=0.05u ad=0.02p as=0.02p pd=0.6u ps=0.6u
m2 vdd E n1 vdd pch w=0.3u l=0.05u ad=0.03p as=0.03p pd=0.8u ps=0.8u
m3 n2 n1 vss vss nch w=0.2u l=0.05u ad=0.02p as=0.02p pd=0.6u ps=0.6u
m4 vdd n1 n2 vdd pch w=0.3u l=0.05u ad=0.03p as=0.03p pd=0.8u ps=0.8u
m5 D n2 n3 vss nch w=0.2u l=0.05u ad=0.02p as=0.02p pd=0.6u ps=0.6u
m6 D n1 n3 vdd pch w=0.3u l=0.05u ad=0.03p as=0.03p pd=0.8u ps=0.8u
m7 n4 n3 vss vss nch w=0.2u l=0.05u ad=0.02p as=0.02p pd=0.6u ps=0.6u
m8 vdd n3 n4 vdd pch w=0.3u l=0.05u ad=0.03p as=0.03p pd=0.8u ps=0.8u
m9 n3 n1 n5 vss nch w=0.2u l=0.05u ad=0.02p as=0.02p pd=0.6u ps=0.6u
m10 n5 n4 vss vss nch w=0.2u l=0.05u ad=0.02p as=0.02p pd=0.6u ps=0.6u
m11 n3 n2 n6 vdd pch w=0.3u l=0.05u ad=0.03p as=0.03p pd=0.8u ps=0.8u
m12 n6 n4 vdd vdd pch w=0.3u l=0.05u ad=0.03p as=0.03p pd=0.8u ps=0.8u
m13 Q n4 vss vss nch w=0.4u l=0.05u ad=0.04p as=0.04p pd=1u ps=1u
m14 vdd n4 Q vdd pch w=0.6u l=0.05u ad=0.06p as=0.06p pd=1.4u ps=1.4u
.ends

.subckt dll_x1 d en q vdd vss
m1 n1 EN vss vss nch w=0.2u l=0.05u ad=0.02p as=0.02p pd=0.6u ps=0.6u
m2 vdd EN n1 vdd pch w=0.3u l=0.05u ad=0.03p as=0.03p pd=0.8u ps=0.8u
m3 n2 n1 vss vss nch w=0.2u l=0.05u ad=0.02p as=0.02p pd=0.6u ps=0.6u
m4 vdd n1 n2 vdd pch w=0.3u l=0.05u ad=0.03p as=0.03p pd=0.8u ps=0.8u
m5 D n1 n3 vss nch w=0.2u l=0.05u ad=0.02p as=0.02p pd=0.6u ps=0.6u
m6 D n2 n3 vdd pch w=0.3u l=0.05u ad=0.03p as=0.03p pd=0.8u ps=0.8u
m7 n4 n3 vss vss nch w=0.2u l=0.05u ad=0.02p as=0.02p pd=0.6u ps=0.6u
m8 vdd n3 n4 vdd pch w=0.3u l=0.05u ad=0.03p as=0.03p pd=0.8u ps=0.8u
m9 n3 n2 n5 vss nch w=0.2u l=0.05u ad=0.02p as=0.02p pd=0.6u ps=0.6u
m10 n5 n4 vss vss nch w=0.2u l=0.05u ad=0.02p as=0.02p pd=0.6u ps=0.6u
m11 n3 n1 n6 vdd pch w=0.3u l=0.05u ad=0.03p as=0.03p pd=0.8u ps=0.8u
m12 n6 n4 vdd vdd pch w=0.3u l=0.05u ad=0.03p as=0.03p pd=0.8u ps=0.8u
m13 Q n4 vss vss nch w=0.2u l=0.05u ad=0.02p as=0.02p pd=0.6u ps=0.6u
m14 vdd n4 Q vdd pch w=0.3u l=0.05u ad=0.03p as=0.03p pd=0.8u ps=0.8u
.ends

.subckt clkgate_x1 ck e se gck vdd vss
m1 n1 CK vss vss nch w=0.2u l=0.05u ad=0.02p as=0.02p pd=0.6u ps=0.6u
m2 vdd CK n1 vdd pch w=0.3u l=0.05u ad=0.03p as=0.03p pd=0.8u ps=0.8u
m3 n2 n1 vss vss nch w=0.2u l=0.05u ad=0.02p as=0.02p pd=0.6u ps=0.6u
m4 vdd n1 n2 vdd pch w=0.3u l=0.05u ad=0.03p as=0.03p pd=0.8u ps=0.8u
m5 n5 E vss vss nch w=0.2u l=0.05u ad=0.02p as=0.02p pd=0.6u ps=0.6u
m6 n5 SE vss vss nch w=0.2u l=0.05u ad=0.02p as=0.02p pd=0.6u ps=0.6u
m7 vdd E n6 vdd pch w=0.6u l=0.05u ad=0.06p as=0.06p pd=1.4u ps=1.4u
m8 n6 SE n5 vdd pch w=0.6u l=0.05u ad=0.06p as=0.06p pd=1.4u ps=1.4u
m9 n5 n1 n3 vss nch w=0.2u l=0.05u ad=0.02p as=0.02p pd=0.6u ps=0.6u
m10 n5 n2 n3 vdd pch w=0.3u l=0.05u ad=0.03p as=0.03p pd=0.8u ps=0.8u
m11 n4 n3 vss vss nch w=0.2u l=0.05u ad=0.02p as=0.02p pd=0.6u ps=0.6u
m12 vdd n3 n4 vdd pch w=0.3u l=0.05u ad=0.03p as=0.03p pd=0.8u ps=0.8u
m13 n3 n2 n7 vss nch w=0.2u l=0.05u ad=0.02p as=0.02p pd=0.6u ps=0.6u
m14 n7 n4 vss vss nch w=0.2u l=0.05u ad=0.02p as=0.02p pd=0.6u ps=0.6u
m15 n3 n1 n8 vdd pch w=0.3u l=0.05u ad=0.03p as=0.03p pd=0.8u ps=0.8u
m16 n8 n4 vdd vdd pch w=0.3u l=0.05u ad=0.03p as=0.03p pd=0.8u ps=0.8u
m17 n9 CK n10 vss nch w=0.4u l=0.05u ad=0.04p as=0.04p pd=1u ps=1u
m18 n10 n4 vss vss nch w=0.4u l=0.05u ad=0.04p as=0.04p pd=1u ps=1u
m19 vdd CK n9 vdd pch w=0.3u l=0.05u ad=0.03p as=0.03p pd=0.8u ps=0.8u
m20 vdd n4 n9 vdd pch w=0.3u l=0.05u ad=0.03p as=0.03p pd=0.8u ps=0.8u
m21 GCK n9 vss vss nch w=0.2u l=0.05u ad=0.02p as=0.02p pd=0.6u ps=0.6u
m22 vdd n9 GCK vdd pch w=0.3u l=0.05u ad=0.03p as=0.03p pd=0.8u ps=0.8u
.ends

.subckt clkgate_x2 ck e se gck vdd vss
m1 n1 CK vss vss nch w=0.2u l=0.05u ad=0.02p as=0.02p pd=0.6u ps=0.6u
m2 vdd CK n1 vdd pch w=0.3u l=0.05u ad=0.03p as=0.03p pd=0.8u ps=0.8u
m3 n2 n1 vss vss nch w=0.2u l=0.05u ad=0.02p as=0.02p pd=0.6u ps=0.6u
m4 vdd n1 n2 vdd pch w=0.3u l=0.05u ad=0.03p as=0.03p pd=0.8u ps=0.8u
m5 n5 E vss vss nch w=0.2u l=0.05u ad=0.02p as=0.02p pd=0.6u ps=0.6u
m6 n5 SE vss vss nch w=0.2u l=0.05u ad=0.02p as=0.02p pd=0.6u ps=0.6u
m7 vdd E n6 vdd pch w=0.6u l=0.05u ad=0.06p as=0.06p pd=1.4u ps=1.4u
m8 n6 SE n5 vdd pch w=0.6u l=0.05u ad=0.06p as=0.06p pd=1.4u ps=1.4u
m9 n5 n1 n3 vss nch w=0.2u l=0.05u ad=0.02p as=0.02p pd=0.6u ps=0.6u
m10 n5 n2 n3 vdd pch w=0.3u l=0.05u ad=0.03p as=0.03p pd=0.8u ps=0.8u
m11 n4 n3 vss vss nch w=0.2u l=0.05u ad=0.02p as=0.02p pd=0.6u ps=0.6u
m12 vdd n3 n4 vdd pch w=0.3u l=0.05u ad=0.03p as=0.03p pd=0.8u ps=0.8u
m13 n3 n2 n7 vss nch w=0.2u l=0.05u ad=0.02p as=0.02p pd=0.6u ps=0.6u
m14 n7 n4 vss vss nch w=0.2u l=0.05u ad=0.02p as=0.02p pd=0.6u ps=0.6u
m15 n3 n1 n8 vdd pch w=0.3u l=0.05u ad=0.03p as=0.03p pd=0.8u ps=0.8u
m16 n8 n4 vdd vdd pch w=0.3u l=0.05u ad=0.03p as=0.03p pd=0.8u ps=0.8u
m17 n9 CK n10 vss nch w=0.4u l=0.05u ad=0.04p as=0.04p pd=1u ps=1u
m18 n10 n4 vss vss nch w=0.4u l=0.05u ad=0.04p as=0.04p pd=1u ps=1u
m19 vdd CK n9 vdd pch w=0.3u l=0.05u ad=0.03p as=0.03p pd=0.8u ps=0.8u
m20 vdd n4 n9 vdd pch w=0.3u l=0.05u ad=0.03p as=0.03p pd=0.8u ps=0.8u
m21 GCK n9 vss vss nch w=0.4u l=0.05u ad=0.04p as=0.04p pd=1u ps=1u
m22 vdd n9 GCK vdd pch w=0.6u l=0.05u ad=0.06p as=0.06p pd=1.4u ps=1.4u
.ends

.subckt clkgate_x4 ck e se gck vdd vss
m1 n1 CK vss vss nch w=0.2u l=0.05u ad=0.02p as=0.02p pd=0.6u ps=0.6u
m2 vdd CK n1 vdd pch w=0.3u l=0.05u ad=0.03p as=0.03p pd=0.8u ps=0.8u
m3 n2 n1 vss vss nch w=0.2u l=0.05u ad=0.02p as=0.02p pd=0.6u ps=0.6u
m4 vdd n1 n2 vdd pch w=0.3u l=0.05u ad=0.03p as=0.03p pd=0.8u ps=0.8u
m5 n5 E vss vss nch w=0.2u l=0.05u ad=0.02p as=0.02p pd=0.6u ps=0.6u
m6 n5 SE vss vss nch w=0.2u l=0.05u ad=0.02p as=0.02p pd=0.6u ps=0.6u
m7 vdd E n6 vdd pch w=0.6u l=0.05u ad=0.06p as=0.06p pd=1.4u ps=1.4u
m8 n6 SE n5 vdd pch w=0.6u l=0.05u ad=0.06p as=0.06p pd=1.4u ps=1.4u
m9 n5 n1 n3 vss nch w=0.2u l=0.05u ad=0.02p as=0.02p pd=0.6u ps=0.6u
m10 n5 n2 n3 vdd pch w=0.3u l=0.05u ad=0.03p as=0.03p pd=0.8u ps=0.8u
m11 n4 n3 vss vss nch w=0.2u l=0.05u ad=0.02p as=0.02p pd=0.6u ps=0.6u
m12 vdd n3 n4 vdd pch w=0.3u l=0.05u ad=0.03p as=0.03p pd=0.8u ps=0.8u
m13 n3 n2 n7 vss nch w=0.2u l=0.05u ad=0.02p as=0.02p pd=0.6u ps=0.6u
m14 n7 n4 vss vss nch w=0.2u l=0.05u ad=0.02p as=0.02p pd=0.6u ps=0.6u
m15 n3 n1 n8 vdd pch w=0.3u l=0.05u ad=0.03p as=0.03p pd=0.8u ps=0.8u
m16 n8 n4 vdd vdd pch w=0.3u l=0.05u ad=0.03p as=0.03p pd=0.8u ps=0.8u
m17 n9 CK n10 vss nch w=0.53333u l=0.05u ad=0.05333p as=0.05333p pd=1.26667u ps=1.26667u
m18 n10 n4 vss vss nch w=0.53333u l=0.05u ad=0.05333p as=0.05333p pd=1.26667u ps=1.26667u
m19 vdd CK n9 vdd pch w=0.4u l=0.05u ad=0.04p as=0.04p pd=1u ps=1u
m20 vdd n4 n9 vdd pch w=0.4u l=0.05u ad=0.04p as=0.04p pd=1u ps=1u
m21 GCK n9 vss vss nch w=0.8u l=0.05u ad=0.08p as=0.08p pd=1.8u ps=1.8u
m22 vdd n9 GCK vdd pch w=1.2u l=0.05u ad=0.12p as=0.12p pd=2.6u ps=2.6u
.ends

.subckt tie0 y vdd vss
m1 n1 n1 vdd vdd pch w=0.3u l=0.05u ad=0.03p as=0.03p pd=0.8u ps=0.8u
m2 Y n1 vss vss nch w=0.2u l=0.05u ad=0.02p as=0.02p pd=0.6u ps=0.6u
.ends

.subckt tie1 y vdd vss
m1 n1 n1 vss vss nch w=0.2u l=0.05u ad=0.02p as=0.02p pd=0.6u ps=0.6u
m2 Y n1 vdd vdd pch w=0.3u l=0.05u ad=0.03p as=0.03p pd=0.8u ps=0.8u
.ends

.subckt fill1  vdd vss
.ends

.subckt fill2  vdd vss
.ends

.subckt fill4  vdd vss
.ends

.subckt fill8  vdd vss
.ends
