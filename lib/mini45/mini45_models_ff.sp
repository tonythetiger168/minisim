* mini45 ff corner: device models and conditions for the cell netlists.
* Made up, not a foundry model. Generated by gen_mini45.py; do not edit.
* Supply and temperature come from the Liberty corner: 1.25 V, -40 C.
.model nch nmos level=1 vto=0.3 kp=0.000124 tox=2n gamma=0.3 phi=0.7 lambda=0.1 cgso=0.15n cgdo=0.15n cj=1.2m mj=0.5 cjsw=0.25n mjsw=0.33 pb=0.8
.model pch pmos level=1 vto=-0.3 kp=6.4e-05 tox=2n gamma=0.3 phi=0.7 lambda=0.1 cgso=0.15n cgdo=0.15n cj=1.2m mj=0.5 cjsw=0.25n mjsw=0.33 pb=0.8
