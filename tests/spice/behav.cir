behavioral sources: B elements, E and G with expressions
* sq:  v = k v(in)^2 = 2 * 9 = 18
* lim: i = limit(3, -0.5, 0.5) mA into 1k = 0.5
* pw:  i(vs) = 3/2k = 1.5 mA; 1.5m * 5 * 1k = 7.5
* ab:  |v(neg)| = 2;  gg: tanh(3 * -2) mA into 1k = -0.999988
* dio: a behavioral diode fed 1 mA: v = 0.025 ln(1e-3/1e-12 + 1) = 0.518082
* fb:  v(fb) = 1 + v(fb)/2 (its own output on the right): 2
.param k=2
v1 in 0 3
v2 neg 0 -2
vdd vdd 0 5
b1 sq 0 v = v(in)*v(in)*k
r2 sq 0 1k
b2 0 lim i = limit(v(in), -0.5, 0.5) * 1m
r3 lim 0 1k
vs sense 0 0
r4 in sense 2k
b3 pw 0 v = {i(vs) * v(vdd) * 1k}
r5 pw 0 1k
e1 ab 0 vol='abs(v(neg))'
r6 ab 0 1k
g1 0 gg cur='tanh(3*v(neg))*1m'
r7 gg 0 1k
i1 0 dio 1m
b4 dio 0 i = 1e-12*(exp(v(dio)/0.025)-1)
b5 fb 0 v = 1 + v(fb,0)/2
r8 fb 0 1k
.dc v1 3 3 1
.meas dc sq max v(sq)
.meas dc lim max v(lim)
.meas dc pw max v(pw)
.meas dc ab max v(ab)
.meas dc gg max v(gg)
.meas dc dio max v(dio)
.meas dc fb max v(fb)
*> sq 18 1e-9
*> lim 0.5 1e-9
*> pw 7.5 1e-9
*> ab 2 1e-9
*> gg -0.999988 1e-6
*> dio 0.518082 1e-5
*> fb 2 1e-6
*> no-ngspice
.end
