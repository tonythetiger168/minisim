A MOSFET level mspice does not have
.model n54 nmos level=54 vth0=0.4
v1 d 0 1
m1 d d 0 0 n54 w=1u l=0.1u
.op
*> error "MOSFET level 54; mspice has level 1 only so far"
.end
