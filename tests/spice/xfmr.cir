Coupled inductors: open-circuit voltage ratio and loaded transfer
* Open secondary: v2/v1 = M/L1 = k sqrt(L2/L1) = 0.9 * 2 = 1.8.
v1 p 0 dc 0 ac 1 sin(0 1 10k)
rs p p1 1m
l1 p1 0 1m
l2 s 0 4m
k1 l1 l2 0.9
rl s 0 1meg
l3 p1 q 2m
l4 t 0 2m
k2 l3 l4 0.5
r3 q 0 50
r4 t 0 100
.ac dec 10 1k 100k
.tran 1u 400u
.meas ac ratio find vm(s) at=10k
.meas ac vt find vm(t) at=10k
.meas tran v2pk max v(s) from=200u to=400u
.meas tran vtpk max v(t) from=200u to=400u
*> ratio 1.8 1e-3
*> v2pk 1.8 5e-3
.end
