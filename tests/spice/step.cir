.step over a parameter: RC time constant
* t63 = R C + half the 1 us rise time, for each R.
.param r=1k
v1 in 0 pulse(0 1 0 1u 1u 1 2)
r1 in out {r}
c1 out 0 100n
.step param r list 1k 2k 5k
.tran 5u 2m
.meas tran t63 when v(out)=0.632120559 rise=1
*> t63@1 1.005e-4 1e-3
*> t63@2 2.005e-4 1e-3
*> t63@3 5.005e-4 1e-3
*> no-ngspice
.end
