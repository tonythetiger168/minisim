a switch in a transient: a relaxation of an RC through a switch
* The control ramps 0 to 1 V in 1 ms; the switch (vt 0.5, vh 0.1) closes at
* 0.6 ms and connects 5 V to an RC (1k, 100n, tau = 0.1 ms). v(out)
* reaches 5 (1 - 1/e) = 3.160603 one tau later, at 0.7 ms.
vdd vdd 0 5
vc c 0 pwl(0 0 1m 1)
s1 vdd a c 0 swh
rl a 0 1k
r1 a out 1k
c1 out 0 100n
.model swh sw vt=0.5 vh=0.1 ron=0.1 roff=1g
.tran 1u 1.2m 0 1u
.meas tran ton when v(a)=2.5 rise=1
.meas tran t63 when v(out)=3.160603 rise=1
*> ton 6.0e-4 5e-3
*> t63 7.0e-4 5e-3
*> no-ngspice
.end
