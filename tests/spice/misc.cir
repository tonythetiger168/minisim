Sources, .include, .global, .nodeset, .temp, nested .dc
* (1) PWL into an RC with a long time constant follows the input's integral.
* (2) A current source into a resistor: v = I R.
* (3) Two cross-coupled sinking stages have two stable states; .nodeset picks
*     the one with la high.
* (4) At 77 C the thermal voltage is 30.174 mV; the two-diode ratio gives
*     v(d1) - v(d2) = Vt ln(10) = 69.478 mV for a 10:1 current ratio.
.include "misc_inc.inc"
.global vcc
.temp 77
vcc vcc 0 5
* (1), (2)
vp p 0 pwl(0 0 1m 1 2m 1 3m 0)
rp p q 1k
cq q 0 1u
i1 0 r dc 2m
rr r 0 1.5k
ve e 0 exp(0 1 0 1m 5m 1m)
vs s 0 sin(1 0.5 1k 1m)
re e 0 1k
rs s 0 1k
* (3)
x1 la pullup r=4.7k
x2 lb pullup r=4.7k
g1 la 0 lb 0 2m
g2 lb 0 la 0 2m
dla la 0 dz
dlb lb 0 dz
.nodeset v(la)=0.7 v(lb)=0
* (4)
i2 0 d1 dc 1m
i3 0 d2 dc 100u
dd1 d1 0 dz
dd2 d2 0 dz
vx x 0 0
ex y 0 x 0 1
ry y 0 1k
.dc vx 0 1 0.5 i1 1m 2m 1m
.tran 10u 6m
.meas dc vr find v(r) at=0.5
.meas tran vq find v(q) at=2m
.meas tran ve3 find v(e) at=3m
.meas tran vs find v(s) at=1.25m
.meas tran vla find v(la) at=1m
.meas tran vlb find v(lb) at=1m
.meas tran dv find v(d1,d2) at=1m
* v(q) at 2 ms: ramp response tau=1ms: at t=1m, v = 1 - (1 - e^-1) = 0.36788;
* then toward 1: 1 - (1 - 0.36788) e^-1 = 0.76746.
*> vr 1.5 1e-6
*> vla 0.5855 2e-3
*> vq 0.76746 1e-3
*> ve3 0.950213 1e-3
*> vs 1.5 1e-3
*> dv 69.478e-3 1e-3 mspice-only
*> ngspice 0.01
.end
