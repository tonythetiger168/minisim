Diode: forward drop, small-signal resistance, rectifier with a filter capacitor
* 5 V through 1k into IS = 1e-14: Vd = Vt ln(I/IS + 1) with Vt = 25.865 mV
* gives Vd = 0.692888 V, I = 4.30711 mA. rd = Vt/I = 6.005 ohm, so the AC
* divider is rd/(1k + rd) = 5.9693e-3.
.model dx d is=1e-14
.model dr d is=1e-12 n=1.5 rs=2 cjo=20p vj=0.7 m=0.4 tt=5n bv=40
v1 in 0 dc 5 ac 1
r1 in d 1k
d1 d 0 dx
* rectifier
v2 src 0 sin(0 10 1k)
d2 src rect dr
c2 rect 0 10u
r2 rect 0 1k
* reverse breakdown clamp
v3 z1 0 dc -50
r3 z1 z2 1k
d3 z2 0 dr
.dc v1 0 5 0.25
.ac lin 3 1k 3k
.tran 10u 5m
.meas dc vd find v(d) at=5
.meas dc id find i(v1) at=5
.meas dc vz find v(z2) at=5
.meas ac gain find vm(d) at=2k
.meas tran vmax max v(rect)
.meas tran vrip pp v(rect) from=3m to=5m
.meas tran vavg avg v(rect) from=3m to=5m
*> vd 0.692888 1e-4
*> id -4.30711e-3 1e-4
*> gain 5.9693e-3 1e-3
.end
