Monte Carlo: global and per-instance variation
* rv is a top-level parameter: one draw per run, shared by r1 and r2, so
* v(b) is 0.5 in every run whatever the draw. rr is a parameter of the
* subcircuit: each instance draws its own, so v(c) and v(d) differ.
* The draws depend only on the seed and the run number, never on threads.
.param rv=agauss(1k,100,1)
.option seed=7
v1 a 0 1
r1 a b rv
r2 b 0 rv
e1 s 0 b 0 1
x1 s c div
x2 s d div
.subckt div i o
.param rr=gauss(1k,0.1,1)
r1 i o rr
r2 o 0 1k
.ends
.dc v1 1 1 1
.meas dc vb max v(b)
.meas dc vc max v(c)
.meas dc vd max v(d)
.meas dc diff max v(c,d)
.step monte 4
*> vb@1 0.5 1e-9
*> vb@4 0.5 1e-9
* Seed 7, run 1: pins the generator so a change to it is noticed.
*> vc@1 2.677015e-01 1e-5
*> vd@1 2.510184e-01 1e-5
*> no-ngspice
.end
