BSIM4 options that add internal nodes, and a ring large enough for threads
* Gate resistance with a middle node (rgatemod=3), a body resistance network
* (rbodymod=1), bias-dependent source/drain resistance (rdsmod=1) and the
* non-quasi-static charge model in time and AC (trnqsmod, acnqsmod): each adds
* internal nodes or frequency-dependent stamps. The ring of 17 inverters (34
* transistors) is evaluated on several threads. Expected values are ngspice's.
.model nx nmos level=54 version=4.8.3 toxe=1.8n vth0=0.4 u0=0.04 vsat=1.2e5 rdsw=150
+ k1=0.5 k2=-0.05 eta0=0.02 pclm=1.2 cgso=0.2n cgdo=0.2n cjs=1m cjd=1m
+ rgatemod=3 rshg=10 xgw=0.1u ngcon=1 rbodymod=1 rdsmod=1 rsh=5 trnqsmod=1 acnqsmod=1
.model nch nmos level=54 version=4.8.3 toxe=1.8n vth0=0.4 u0=0.04 vsat=1.2e5 rdsw=150
+ k1=0.5 k2=-0.05 eta0=0.02 pclm=1.2 cgso=0.2n cgdo=0.2n cjs=1m cjd=1m cjsws=0.1n cjswd=0.1n
.model pch pmos level=54 version=4.8.3 toxe=1.9n vth0=-0.42 u0=0.012 vsat=1.0e5 rdsw=250
+ k1=0.5 k2=-0.03 eta0=0.02 pclm=1.2 cgso=0.2n cgdo=0.2n cjs=1m cjd=1m cjsws=0.1n cjswd=0.1n
vdd vdd 0 1.0
* a stage with every option
vin ain 0 dc 0.75 ac 1 pulse(0.75 0.85 1n 50p 50p 1n 4n)
rl vdd aout 20k
mx aout ain 0 0 nx w=2u l=100n nrd=1 nrs=1 ad=0.2p as=0.2p pd=2.2u ps=2.2u
cla aout 0 10f
* the ring
.subckt inv a y vdd
mp y a vdd vdd pch w=400n l=50n ad=40f as=40f pd=1u ps=1u
mn y a 0 0 nch w=200n l=50n ad=20f as=20f pd=0.6u ps=0.6u
.ends
x1 r17 r1 vdd inv
x2 r1 r2 vdd inv
x3 r2 r3 vdd inv
x4 r3 r4 vdd inv
x5 r4 r5 vdd inv
x6 r5 r6 vdd inv
x7 r6 r7 vdd inv
x8 r7 r8 vdd inv
x9 r8 r9 vdd inv
x10 r9 r10 vdd inv
x11 r10 r11 vdd inv
x12 r11 r12 vdd inv
x13 r12 r13 vdd inv
x14 r13 r14 vdd inv
x15 r14 r15 vdd inv
x16 r15 r16 vdd inv
x17 r16 r17 vdd inv
.ic v(r1)=0 v(r2)=1 v(r3)=0
.ac dec 10 1meg 100g
.measure ac gain max vdb(aout)
.measure ac f3db when vdb(aout)=10 fall=1
.tran 2p 3n
.measure tran period trig v(r1) val=0.5 rise=3 targ v(r1) val=0.5 rise=4
.measure tran swing pp v(aout) from=0.9n to=3n
.measure tran lag trig v(ain) val=0.8 rise=1 targ v(aout) val=0.35 fall=1
*> gain 17.144 0.01
*> f3db 2.057e9 0.01
*> period 8.627e-10 0.02
*> swing 0.4130 0.02
*> lag 2.344e-11 0.03
.end
