.tf and .sens of a divider
* v(out) = v1 r2/(r1+r2) = 7.5: gain 0.75, the source sees 4k, the output
* shows 1k || 3k = 750. d v(out)/d r1 = -v1 r2/(r1+r2)^2 = -1.875e-3,
* d v(out)/d r2 = v1 r1/(r1+r2)^2 = 6.25e-4, d v(out)/d i1 = 750.
v1 in 0 10
r1 in out 1k
r2 out 0 3k
i1 0 out 0
.tf v(out) v1
.sens v(out)
*> transfer_function 0.75 1e-9
*> input_resistance 4000 1e-9
*> output_resistance 750 1e-9
*> v1 0.75 1e-9
*> r1 -1.875e-3 1e-9
*> r2 6.25e-4 1e-9
*> i1 750 1e-9
*> no-ngspice
.end
