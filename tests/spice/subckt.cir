Subcircuits, parameters and expressions
* Two RC sections built from one .subckt, with different parameters, and a
* nested subcircuit. A unity buffer between them keeps the stages apart, so
* each is a plain first-order low-pass: corner 1/(2 pi R C).
.param rbase=1k cbase={100n*2} k=3
.subckt rc in out r=1k c=1n
r1 in out {r}
c1 out 0 {c}
.ends
.subckt buffered in out gain=1 r=1k c=1n
x1 in mid rc r={r} c={c}
e1 out 0 mid 0 {gain}
.ends
.subckt divider top tap params: ratio=0.5 rtotal=10k
.param rlow={rtotal*ratio}
ra top tap {rtotal - rlow}
rb tap 0 {rlow}
.ends
v1 in 0 dc 1 ac 1
xa in a buffered r={rbase} c={cbase}
xb a b buffered gain=2 r={rbase*k} c='cbase/2'
xd b d divider ratio=0.25
.op
.ac dec 50 10 100k
.meas ac fa when vdb(a)=-3.0103
.meas ac fb when vdb(xb.mid)=-6.0206 fall=1
.meas ac gb find vm(b) at=10
.meas ac gd find vm(d) at=10
* fa = 1/(2 pi 1k 200n) = 795.77 Hz. xb.mid is -3 dB (from xa) and -3 dB more
* where both corners bite; its own corner is 1/(2 pi 3k 100n) = 530.5 Hz.
*> fa 795.77 2e-3
*> gb 2.0 1e-3
*> gd 0.5 1e-3
*> no-ngspice
.end
