Parallel model evaluation gives the same answer
* parmin=1 sends even this small circuit through the worker threads; the
* check script compares the output of -threads 1, 3 and all byte for byte.
.option parmin=1
.model nch nmos vto=0.7 kp=100u gamma=0.4 phi=0.65 lambda=0.02 tox=20n cgso=0.3n cgdo=0.3n cj=0.4m cjsw=0.3n
.model pch pmos vto=-0.8 kp=40u gamma=0.5 phi=0.65 lambda=0.03 tox=20n cgso=0.3n cgdo=0.3n cj=0.5m cjsw=0.3n
.model dx d is=1e-14 cjo=1p tt=1n
.model qx npn is=1e-16 bf=100 cje=1p cjc=0.5p tf=0.2n
.subckt inv in out vdd
mp out in vdd vdd pch w=20u l=1u ad=40p as=40p pd=24u ps=24u
mn out in 0 0 nch w=10u l=1u ad=20p as=20p pd=14u ps=14u
.ends
vdd vdd 0 3.3
vin n0 0 pulse(0 3.3 1n 0.2n 0.2n 4n 10n)
x1 n0 n1 vdd inv
x2 n1 n2 vdd inv
x3 n2 n3 vdd inv
x4 n3 n4 vdd inv
x5 n4 n5 vdd inv
x6 n5 n6 vdd inv
x7 n6 n7 vdd inv
x8 n7 n8 vdd inv
d1 n8 c1 dx
d2 0 c1 dx
r1 c1 b1 10k
q1 k1 b1 0 qx
r2 vdd k1 2k
.tran 10p 10n
.meas tran d8 trig v(n0) val=1.65 rise=1 targ v(n8) val=1.65 rise=1
.meas tran vk min v(k1)
*> ngspice 0.02
.end
