.four: harmonics and distortion
* A 1 V sine with 0.1 V of third harmonic: 10 % distortion. The same through
* a diode clipper gives 13.6103 % in ngspice 42.
v1 a 0 sin(0 1 1k)
v3 b a sin(0 0.1 3k)
rl b 0 1k
r1 a c 1k
d1 c 0 dm
.model dm d is=1e-14
.tran 1u 5m
.four 1k v(b) v(c)
*> thd_b 10 1e-4
*> thd_c 13.6103 1e-3
*> no-ngspice
.end
