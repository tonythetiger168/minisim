MOSFET level 1: drain current, body effect, PMOS, CMOS inverter
* beta = KP W/L = 1e-3, VTO = 0.7, LAMBDA = 0.02.
* Saturation, Vgs = 2, Vds = 3: Id = beta/2 (1.3)^2 (1 + 0.06) = 895.7 uA.
* Linear,     Vgs = 2, Vds = 0.5: Id = beta (1.01) 0.5 (1.3 - 0.25) = 530.25 uA.
.model nch nmos vto=0.7 kp=100u gamma=0.4 phi=0.65 lambda=0.02 tox=20n cgso=0.3n cgdo=0.3n cj=0.4m cjsw=0.3n pb=0.8
.model pch pmos vto=-0.8 kp=40u gamma=0.5 phi=0.65 lambda=0.03 tox=20n cgso=0.3n cgdo=0.3n cj=0.5m cjsw=0.3n pb=0.8
vg g 0 dc 2
vd d 0 dc 3
m1 d g 0 0 nch w=10u l=1u
* body effect: source and bulk apart
vb sb 0 dc -1
vd2 dd 0 dc 3
m2 dd g 0 sb nch w=10u l=1u
* inverter transfer curve
vdd vdd 0 dc 3.3
vin in 0 dc 0 pulse(0 3.3 1n 0.2n 0.2n 4n 10n)
mp out in vdd vdd pch w=20u l=1u ad=40p as=40p pd=24u ps=24u
mn out in 0 0 nch w=10u l=1u ad=20p as=20p pd=14u ps=14u
cl out 0 50f
.dc vd 0 3.3 0.05
.tran 10p 10n
.meas dc idsat find i(vd) at=3
.meas dc idlin find i(vd) at=0.5
.meas dc idbody find i(vd2) at=3
.meas tran tphl trig v(in) val=1.65 rise=1 targ v(out) val=1.65 fall=1
.meas tran tplh trig v(in) val=1.65 fall=1 targ v(out) val=1.65 rise=1
.meas tran vhigh find v(out) at=0.5n
.meas tran vlow find v(out) at=4n
.meas tran idd avg i(vdd) from=0 to=10n
*> idsat -895.7e-6 1e-4
*> idlin -530.25e-6 1e-4
*> vhigh 3.3 1e-3
*> ngspice 0.02
.end
