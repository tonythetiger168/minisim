.noise: thermal noise of a divider, and kT/C
* Two 1k resistors in parallel at the output: 500 ohm, so the density is
* sqrt(4 k T 500) = 2.87888e-9 V/sqrt(Hz) at 27 C (300.15 K). The gain from
* v1 is 0.5, so the input-referred density is twice that. Over all
* frequencies the capacitor holds kT/C: sqrt(4.14402e-21 / 1p) = 6.43741e-5 V.
v1 in 0 dc 1 ac 1
r1 in out 1k
r2 out 0 1k
c1 out 0 1p
.noise v(out) v1 dec 20 1 1e13
.meas noise on1k find onoise at=1k
.meas noise in1k find inoise at=1k
*> on1k 2.87888e-9 1e-5
*> in1k 5.75776e-9 1e-5
*> onoise_total 6.43741e-5 1e-3
*> no-ngspice
.end
