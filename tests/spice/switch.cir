switches: voltage and current controlled, abrupt, with hysteresis, smooth
* on:  1 ohm into 1k from 5 V: 5 * 1000/1001 = 4.995005
* off: 1 Mohm into 1k:        5 * 1/1001    = 4.995005e-3
* smooth, control halfway: R = sqrt(100 * 1meg) = 10k into 10k = 2.5
* hysteresis (vt 0.5, vh 0.25) on a sweep 0 to 1 in steps of 0.1: the output
*   is off up to 0.7 and on from 0.8, so it crosses 2.5 near 0.75
* w1 closes when 2 mA flows in vs (it = 1 mA)
vdd vdd 0 5
vc c 0 1
vlo lo 0 0.5
vs sns 0 0
i1 0 sns 2m
s1 vdd on c 0 sw1
r1 on 0 1k
s2 vdd off 0 c sw1
r2 off 0 1k
s3 vdd sm lo 0 soft
r3 sm 0 10k
s4 vdd hy c 0 swh
r4 hy 0 1k
w1 vdd wo vs cs1
r5 wo 0 1k
.model sw1 sw vt=0.5 ron=1 roff=1meg
.model swh sw vt=0.5 vh=0.25 ron=1 roff=1meg
.model soft vswitch von=1 voff=0 ron=100 roff=1meg
.model cs1 csw it=1m ron=1 roff=1meg
.dc vc 0 1 0.1
.meas dc on find v(on) at=1
.meas dc off find v(off) at=1
.meas dc sm find v(sm) at=1
.meas dc wo find v(wo) at=1
.meas dc von when v(hy)=2.5 rise=1
*> on 4.995005 1e-6
*> off 4.995005e-3 1e-6
*> sm 2.5 1e-6
*> wo 4.995005 1e-6
*> von 0.75 1e-2
*> no-ngspice
.end
