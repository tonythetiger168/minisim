Series RLC: ringing after a step, resonance in AC
* w0 = 1/sqrt(LC) = 31623 rad/s (5032.9 Hz), zeta = (R/2) sqrt(C/L) = 0.1581.
* Step: first peak 1 + exp(-pi zeta / sqrt(1 - zeta^2)) = 1.60468 at 100.6 us.
* AC: at resonance the capacitor voltage is Q = 1/(2 zeta) = 3.1623 (10 dB).
v1 in 0 dc 0 ac 1 pulse(0 1 0 10n 10n 1 2)
r1 in a 10
l1 a b 1m
c1 b 0 1u
.tran 1u 1m
.ac dec 200 100 100k
.meas tran vpeak max v(b)
.meas tran tpeak when v(b)=1.55 rise=1
.meas tran ipeak max i(l1)
.meas ac qdb max vdb(b)
.meas ac fres when vp(b)=-90
*> vpeak 1.60468 2e-3
*> qdb 10.0 0.02
*> fres 5032.9 2e-3 mspice-only
.end
