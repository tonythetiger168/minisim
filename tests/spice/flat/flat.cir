Flattening: hierarchy, parameters, globals, unknown cells
.global vdd
.param wn=1u
.subckt inv in out
mp out in vdd vdd pch w={2*wn} l=0.18u
mn out in gnd gnd nch w=wn l=0.18u m=2
.ends
.subckt buf a y strength=1
x1 a mid inv
x2 mid y inv m=strength
r1 y vdd rpoly w=1u l=20u
c1 mid 0 10f
.ends
.subckt top in out vdd
xb in n1 buf strength=3
xc n1 out buf
xm n1 out vdd sky130_fd_pr__nfet_01v8 w=650000u l=150000u nf=2
d1 out vdd dx 2
q1 out n1 0 npn
q2 out n1 0 sub pnp 4
.ends
vdd vdd 0 1.8
vin a 0 dc 0.9
xt a b vdd top
rl b 0 10k
.end
