BSIM4 (level 54): DC curves, a common-source stage in AC, an inverter in time
* The model code is Berkeley's BSIM4 4.8.3; ngspice runs the same equations,
* so the two must agree closely. The expected values are ngspice's.
.model nch nmos level=54 version=4.8.3 toxe=1.8n vth0=0.4 u0=0.04 vsat=1.2e5 rdsw=150
+ k1=0.5 k2=-0.05 dvt0=2 dvt1=0.6 eta0=0.02 pclm=1.2 cgso=0.2n cgdo=0.2n cgbo=10p
+ cjs=1m cjd=1m cjsws=0.1n cjswd=0.1n jss=1e-4 jsd=1e-4
* The same with gate tunneling current, for the DC curves.
.model nchg nmos level=54 version=4.8.3 toxe=1.8n vth0=0.4 u0=0.04 vsat=1.2e5 rdsw=150
+ k1=0.5 k2=-0.05 dvt0=2 dvt1=0.6 eta0=0.02 pclm=1.2 igcmod=1 igbmod=1
.model pch pmos level=14 version=4.8.3 toxe=1.9n vth0=-0.42 u0=0.012 vsat=1.0e5 rdsw=250
+ k1=0.5 k2=-0.03 eta0=0.02 pclm=1.2 cgso=0.2n cgdo=0.2n cjs=1m cjd=1m cjsws=0.1n cjswd=0.1n
vdd vdd 0 1.0
* DC: one transistor
vg g 0 0.8
vd d 0 1.0
vb b 0 0
m1 d g 0 b nchg w=1u l=50n nf=2 ad=0.1p as=0.1p pd=2.2u ps=2.2u
* AC: common source with a resistor load
vin ain 0 dc 0.75 ac 1
rl vdd aout 20k
m2 aout ain 0 0 nch w=2u l=100n m=2
cla aout 0 10f
* Time: inverter into an inverter
vp in 0 pulse(0 1 100p 20p 20p 200p 500p)
mp1 y in vdd vdd pch w=400n l=50n ad=40f as=40f pd=1u ps=1u
mn1 y in 0 0 nch w=200n l=50n ad=20f as=20f pd=0.6u ps=0.6u
mp2 z y vdd vdd pch w=400n l=50n ad=40f as=40f pd=1u ps=1u
mn2 z y 0 0 nch w=200n l=50n ad=20f as=20f pd=0.6u ps=0.6u
cl z 0 1f
.dc vg 0 1 0.05
.measure dc idsat find i(vd) at=1
.measure dc idlin find i(vd) at=0.6
.measure dc ioff find i(vd) at=0
.measure dc igate find i(vg) at=1
.ac dec 10 1meg 100g
.measure ac gain max vdb(aout)
.measure ac f3db when vdb(aout)=10 fall=1
.tran 1p 500p
.measure tran tphl trig v(in) val=0.5 rise=1 targ v(y) val=0.5 fall=1
.measure tran tplh trig v(in) val=0.5 fall=1 targ v(y) val=0.5 rise=1
.measure tran tz trig v(in) val=0.5 rise=1 targ v(z) val=0.5 rise=1
*> idsat -3.7995e-04 0.01
*> idlin -8.699e-08 0.01
*> ioff -1.000e-12 0.01
*> igate -7.758e-14 0.01
*> gain 18.469 0.01
*> f3db 3.016e9 0.01
*> tphl 1.831e-11 0.02
*> tplh 1.926e-11 0.02
*> tz 5.094e-11 0.02
.end
